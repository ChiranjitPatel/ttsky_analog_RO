* NGSPICE file created from tt_um_analog_RO_parax.ext - technology: sky130A

.subckt tt_um_analog_RO_parax clk rst_n ua[2] ua[3] ua[4] ua[5] ua[6] ua[7] ui_in[0]
+ ui_in[1] ui_in[2] ui_in[6] uio_in[0] uio_in[1] uio_in[2] uio_in[3] uio_in[4] uio_in[5]
+ uio_in[6] uio_in[7] uio_oe[0] uio_oe[1] uio_oe[2] uio_oe[3] uio_oe[4] uio_oe[5]
+ uio_oe[6] uio_oe[7] uio_out[0] uio_out[1] uio_out[2] uio_out[3] uio_out[4] uio_out[5]
+ uio_out[6] uio_out[7] uo_out[1] uo_out[2] uo_out[3] uo_out[4] uo_out[5] uo_out[6]
+ VGND ua[1] ui_in[3] ui_in[5] uo_out[0] ui_in[4] ena ua[0] ui_in[7] VDPWR uo_out[7]
X0 a_28324_3901# a_28188_3741# a_27903_3755# VDPWR sky130_fd_pr__pfet_01v8_hvt ad=0.109 pd=1.08 as=0.0567 ps=0.69 w=0.42 l=0.15
X1 a_28123_3889# a_27631_3850# uo_out[7] uo_out[7] sky130_fd_pr__nfet_01v8 ad=0.066 pd=0.745 as=0.109 ps=1.36 w=0.42 l=0.15
X2 sky130_hd_ro33_nand_0.sky130_hd_inv_1_30.Y sky130_hd_ro33_nand_0.sky130_hd_inv_1_31.Y uo_out[7] uo_out[7] sky130_fd_pr__nfet_01v8 ad=0.0878 pd=0.92 as=0.169 ps=1.82 w=0.65 l=0.15
X3 uo_out[7] sky130_hd_ro47_nand_0.sky130_hd_inv_1_30.Y sky130_hd_ro47_nand_0.sky130_hd_inv_1_29.Y uo_out[7] sky130_fd_pr__nfet_01v8 ad=0.169 pd=1.82 as=0.0878 ps=0.92 w=0.65 l=0.15
X4 VDPWR sky130_hd_ro33_nand_0.sky130_hd_nand2_1_0.Y sky130_hd_ro33_nand_0.sky130_hd_inv_1_31.Y VDPWR sky130_fd_pr__pfet_01v8 ad=0.26 pd=2.52 as=0.135 ps=1.27 w=1 l=0.15
X5 uo_out[7] sky130_hd_ro47_nand_0.sky130_hd_inv_1_10.A sky130_hd_ro47_nand_0.sky130_hd_inv_1_11.A uo_out[7] sky130_fd_pr__nfet_01v8 ad=0.169 pd=1.82 as=0.0878 ps=0.92 w=0.65 l=0.15
X6 uo_out[7] a_28424_3247# a_28855_3301# uo_out[7] sky130_fd_pr__nfet_01v8 ad=0.097 pd=0.975 as=0.109 ps=1.36 w=0.42 l=0.15
X7 uo_out[7] sky130_hd_ro32_nand_0.sky130_hd_inv_1_3.Y sky130_hd_ro32_nand_0.sky130_hd_inv_1_2.Y uo_out[7] sky130_fd_pr__nfet_01v8 ad=0.169 pd=1.82 as=0.0878 ps=0.92 w=0.65 l=0.15
X8 sky130_hd_ro33_nand_0.sky130_hd_inv_1_23.Y sky130_hd_ro33_nand_0.sky130_hd_inv_1_24.Y uo_out[7] uo_out[7] sky130_fd_pr__nfet_01v8 ad=0.0878 pd=0.92 as=0.169 ps=1.82 w=0.65 l=0.15
X9 sky130_hd_xor_block_3.sky130_hd_xor2_1_0.B sky130_hd_xor_block_3.sky130_hd_inv_1_3.A VDPWR VDPWR sky130_fd_pr__pfet_01v8 ad=0.135 pd=1.27 as=0.26 ps=2.52 w=1 l=0.15
X10 sky130_hd_ro41_nand_0.sky130_hd_inv_1_34.Y sky130_hd_ro41_nand_0.sky130_hd_inv_1_35.Y VDPWR VDPWR sky130_fd_pr__pfet_01v8 ad=0.135 pd=1.27 as=0.26 ps=2.52 w=1 l=0.15
X11 sky130_hd_ro41_nand_0.sky130_hd_inv_1_34.Y sky130_hd_ro41_nand_0.sky130_hd_inv_1_35.Y uo_out[7] uo_out[7] sky130_fd_pr__nfet_01v8 ad=0.0878 pd=0.92 as=0.169 ps=1.82 w=0.65 l=0.15
X12 a_27746_1891# sky130_hd_div_by_2_0.Qb VDPWR VDPWR sky130_fd_pr__pfet_01v8_hvt ad=0.0578 pd=0.695 as=0.109 ps=1.36 w=0.42 l=0.15
X13 uo_out[7] sky130_hd_xor_block_3.XOROUT sky130_hd_xor_block_2.sky130_hd_inv_1_3.A uo_out[7] sky130_fd_pr__nfet_01v8 ad=0.169 pd=1.82 as=0.0878 ps=0.92 w=0.65 l=0.15
X14 sky130_hd_ro37_nand_0.sky130_hd_inv_1_1.A sky130_hd_ro37_nand_0.sky130_hd_inv_1_8.Y uo_out[7] uo_out[7] sky130_fd_pr__nfet_01v8 ad=0.0878 pd=0.92 as=0.169 ps=1.82 w=0.65 l=0.15
X15 sky130_hd_xor_block_1.XOROUT sky130_hd_xor_block_1.sky130_hd_xor2_1_0.B a_23186_31740# uo_out[7] sky130_fd_pr__nfet_01v8 ad=0.25 pd=1.42 as=0.0878 ps=0.92 w=0.65 l=0.15
X16 sky130_hd_ro33_nand_0.sky130_hd_inv_1_14.Y sky130_hd_ro33_nand_0.sky130_hd_inv_1_15.Y uo_out[7] uo_out[7] sky130_fd_pr__nfet_01v8 ad=0.0878 pd=0.92 as=0.169 ps=1.82 w=0.65 l=0.15
X17 a_19695_33682# sky130_hd_xor_block_3.sky130_hd_xor2_1_0.A uo_out[7] uo_out[7] sky130_fd_pr__nfet_01v8 ad=0.0878 pd=0.92 as=0.0878 ps=0.92 w=0.65 l=0.15
X18 VDPWR sky130_hd_ro37_nand_0.sky130_hd_inv_1_33.Y sky130_hd_ro37_nand_0.sky130_hd_inv_1_32.Y VDPWR sky130_fd_pr__pfet_01v8 ad=0.26 pd=2.52 as=0.135 ps=1.27 w=1 l=0.15
X19 a_7207_31915# ui_in[4] uo_out[7] uo_out[7] sky130_fd_pr__nfet_01v8 ad=0.0878 pd=0.92 as=0.169 ps=1.82 w=0.65 l=0.15
X20 VDPWR sky130_hd_ro53_nand_0.sky130_hd_inv_1_51.Y sky130_hd_ro53_nand_0.sky130_hd_inv_1_50.Y VDPWR sky130_fd_pr__pfet_01v8 ad=0.26 pd=2.52 as=0.135 ps=1.27 w=1 l=0.15
X21 sky130_hd_ro33_nand_0.sky130_hd_inv_1_9.Y sky130_hd_ro33_nand_0.sky130_hd_inv_1_10.Y VDPWR VDPWR sky130_fd_pr__pfet_01v8 ad=0.135 pd=1.27 as=0.26 ps=2.52 w=1 l=0.15
X22 VDPWR sky130_hd_xor_block_1.sky130_hd_inv_1_3.A sky130_hd_xor_block_1.sky130_hd_xor2_1_0.B VDPWR sky130_fd_pr__pfet_01v8 ad=0.26 pd=2.52 as=0.135 ps=1.27 w=1 l=0.15
X23 uo_out[7] a_24330_35537# a_24259_35563# uo_out[7] sky130_fd_pr__nfet_01v8 ad=0.121 pd=1.09 as=0.0989 ps=0.995 w=0.64 l=0.15
X24 VDPWR sky130_hd_ro41_nand_0.sky130_hd_inv_1_8.A sky130_hd_ro41_nand_0.sky130_hd_inv_1_9.A VDPWR sky130_fd_pr__pfet_01v8 ad=0.26 pd=2.52 as=0.135 ps=1.27 w=1 l=0.15
X25 uo_out[7] sky130_hd_ro41_nand_0.sky130_hd_inv_1_8.A sky130_hd_ro41_nand_0.sky130_hd_inv_1_9.A uo_out[7] sky130_fd_pr__nfet_01v8 ad=0.169 pd=1.82 as=0.0878 ps=0.92 w=0.65 l=0.15
X26 VDPWR sky130_hd_ro32_nand_0.sky130_hd_inv_1_7.Y sky130_hd_ro32_nand_0.sky130_hd_inv_1_6.Y VDPWR sky130_fd_pr__pfet_01v8 ad=0.26 pd=2.52 as=0.135 ps=1.27 w=1 l=0.15
X27 uo_out[7] a_28424_2159# a_28855_2213# uo_out[7] sky130_fd_pr__nfet_01v8 ad=0.097 pd=0.975 as=0.109 ps=1.36 w=0.42 l=0.15
X28 sky130_hd_ro53_nand_0.sky130_hd_inv_1_32.Y sky130_hd_ro53_nand_0.sky130_hd_inv_1_33.Y uo_out[7] uo_out[7] sky130_fd_pr__nfet_01v8 ad=0.0878 pd=0.92 as=0.169 ps=1.82 w=0.65 l=0.15
X29 sky130_hd_ro47_nand_0.sky130_hd_inv_1_33.Y sky130_hd_ro47_nand_0.sky130_hd_inv_1_34.Y VDPWR VDPWR sky130_fd_pr__pfet_01v8 ad=0.135 pd=1.27 as=0.26 ps=2.52 w=1 l=0.15
X30 VDPWR sky130_hd_ro53_nand_0.sky130_hd_inv_1_40.Y sky130_hd_ro53_nand_0.sky130_hd_inv_1_39.Y VDPWR sky130_fd_pr__pfet_01v8 ad=0.26 pd=2.52 as=0.135 ps=1.27 w=1 l=0.15
X31 a_27536_3497# a_27631_3850# VDPWR VDPWR sky130_fd_pr__pfet_01v8_hvt ad=0.166 pd=1.8 as=0.154 ps=1.34 w=0.64 l=0.15
X32 sky130_hd_ro37_nand_0.sky130_hd_inv_1_11.Y sky130_hd_ro37_nand_0.sky130_hd_inv_1_12.Y VDPWR VDPWR sky130_fd_pr__pfet_01v8 ad=0.135 pd=1.27 as=0.26 ps=2.52 w=1 l=0.15
X33 sky130_hd_ro53_nand_0.sky130_hd_inv_1_22.Y sky130_hd_ro53_nand_0.sky130_hd_inv_1_22.A VDPWR VDPWR sky130_fd_pr__pfet_01v8 ad=0.135 pd=1.27 as=0.26 ps=2.52 w=1 l=0.15
X34 a_27831_3345# a_27392_2979# a_27746_2979# uo_out[7] sky130_fd_pr__special_nfet_01v8 ad=0.0621 pd=0.705 as=0.0813 ps=0.83 w=0.36 l=0.15
X35 VDPWR sky130_hd_dfxtp_1_1.Q a_22612_35563# VDPWR sky130_fd_pr__pfet_01v8_hvt ad=0.109 pd=1.36 as=0.0578 ps=0.695 w=0.42 l=0.15
X36 uo_out[7] sky130_hd_xor_block_3.sky130_hd_inv_1_1.Y sky130_hd_xor_block_3.sky130_hd_xor2_1_0.A uo_out[7] sky130_fd_pr__nfet_01v8 ad=0.169 pd=1.82 as=0.0878 ps=0.92 w=0.65 l=0.15
X37 VDPWR sky130_hd_ro53_nand_0.sky130_hd_inv_1_24.Y sky130_hd_ro53_nand_0.sky130_hd_inv_1_13.A VDPWR sky130_fd_pr__pfet_01v8 ad=0.26 pd=2.52 as=0.135 ps=1.27 w=1 l=0.15
X38 VDPWR sky130_hd_ro32_nand_0.sky130_hd_inv_1_4.Y sky130_hd_ro32_nand_0.sky130_hd_inv_1_3.Y VDPWR sky130_fd_pr__pfet_01v8 ad=0.26 pd=2.52 as=0.135 ps=1.27 w=1 l=0.15
X39 sky130_hd_ro32_nand_0.sky130_hd_inv_1_13.Y sky130_hd_ro32_nand_0.sky130_hd_inv_1_14.Y VDPWR VDPWR sky130_fd_pr__pfet_01v8 ad=0.135 pd=1.27 as=0.26 ps=2.52 w=1 l=0.15
X40 a_22936_31990# sky130_hd_xor_block_1.sky130_hd_xor2_1_0.B uo_out[7] uo_out[7] sky130_fd_pr__nfet_01v8 ad=0.0878 pd=0.92 as=0.169 ps=1.82 w=0.65 l=0.15
X41 uo_out[7] sky130_hd_xor_block_0.XORB sky130_hd_xor_block_0.sky130_hd_inv_1_1.Y uo_out[7] sky130_fd_pr__nfet_01v8 ad=0.169 pd=1.82 as=0.0878 ps=0.92 w=0.65 l=0.15
X42 sky130_hd_ro47_nand_0.sky130_hd_inv_1_36.Y sky130_hd_ro47_nand_0.sky130_hd_inv_1_37.Y VDPWR VDPWR sky130_fd_pr__pfet_01v8 ad=0.135 pd=1.27 as=0.26 ps=2.52 w=1 l=0.15
X43 sky130_hd_ro32_nand_0.sky130_hd_inv_1_6.Y sky130_hd_ro32_nand_0.sky130_hd_inv_1_7.Y uo_out[7] uo_out[7] sky130_fd_pr__nfet_01v8 ad=0.0878 pd=0.92 as=0.169 ps=1.82 w=0.65 l=0.15
X44 sky130_hd_ro33_nand_0.sky130_hd_inv_1_27.Y sky130_hd_ro33_nand_0.sky130_hd_inv_1_28.Y VDPWR VDPWR sky130_fd_pr__pfet_01v8 ad=0.135 pd=1.27 as=0.26 ps=2.52 w=1 l=0.15
X45 uo_out[7] sky130_hd_ro47_nand_0.sky130_hd_inv_1_13.A sky130_hd_ro47_nand_0.sky130_hd_inv_1_14.A uo_out[7] sky130_fd_pr__nfet_01v8 ad=0.169 pd=1.82 as=0.0878 ps=0.92 w=0.65 l=0.15
X46 VDPWR sky130_hd_ro32_nand_0.sky130_hd_inv_1_1.Y ua[0] VDPWR sky130_fd_pr__pfet_01v8 ad=0.26 pd=2.52 as=0.135 ps=1.27 w=1 l=0.15
X47 uo_out[7] sky130_hd_ro53_nand_0.sky130_hd_inv_1_47.Y sky130_hd_ro53_nand_0.sky130_hd_inv_1_46.Y uo_out[7] sky130_fd_pr__nfet_01v8 ad=0.169 pd=1.82 as=0.0878 ps=0.92 w=0.65 l=0.15
X48 a_27831_2257# a_27392_1891# a_27746_1891# uo_out[7] sky130_fd_pr__special_nfet_01v8 ad=0.0621 pd=0.705 as=0.0813 ps=0.83 w=0.36 l=0.15
X49 a_27957_2979# a_27558_2979# a_27831_3345# uo_out[7] sky130_fd_pr__special_nfet_01v8 ad=0.0696 pd=0.765 as=0.0621 ps=0.705 w=0.36 l=0.15
X50 VDPWR sky130_hd_ro41_nand_0.sky130_hd_inv_1_26.Y sky130_hd_ro41_nand_0.sky130_hd_inv_1_25.Y VDPWR sky130_fd_pr__pfet_01v8 ad=0.26 pd=2.52 as=0.135 ps=1.27 w=1 l=0.15
X51 VDPWR sky130_hd_ro53_nand_0.sky130_hd_inv_1_48.Y sky130_hd_ro53_nand_0.sky130_hd_inv_1_47.Y VDPWR sky130_fd_pr__pfet_01v8 ad=0.26 pd=2.52 as=0.135 ps=1.27 w=1 l=0.15
X52 sky130_hd_ro53_nand_0.sky130_hd_inv_1_41.Y sky130_hd_ro53_nand_0.sky130_hd_inv_1_41.A uo_out[7] uo_out[7] sky130_fd_pr__nfet_01v8 ad=0.0878 pd=0.92 as=0.169 ps=1.82 w=0.65 l=0.15
X53 sky130_hd_xor_block_2.XOROUT a_21179_33268# a_21429_33268# VDPWR sky130_fd_pr__pfet_01v8 ad=0.3 pd=2.6 as=0.26 ps=2.52 w=1 l=0.15
X54 VDPWR sky130_hd_ro37_nand_0.sky130_hd_inv_1_30.Y sky130_hd_ro37_nand_0.sky130_hd_inv_1_29.Y VDPWR sky130_fd_pr__pfet_01v8 ad=0.26 pd=2.52 as=0.135 ps=1.27 w=1 l=0.15
X55 uo_out[7] sky130_hd_ro41_nand_0.sky130_hd_inv_1_26.Y sky130_hd_ro41_nand_0.sky130_hd_inv_1_25.Y uo_out[7] sky130_fd_pr__nfet_01v8 ad=0.169 pd=1.82 as=0.0878 ps=0.92 w=0.65 l=0.15
X56 sky130_hd_ro33_nand_0.sky130_hd_inv_1_6.Y sky130_hd_ro33_nand_0.sky130_hd_inv_1_7.Y VDPWR VDPWR sky130_fd_pr__pfet_01v8 ad=0.135 pd=1.27 as=0.26 ps=2.52 w=1 l=0.15
X57 sky130_hd_ro53_nand_0.sky130_hd_inv_1_14.A sky130_hd_ro53_nand_0.sky130_hd_inv_1_13.A VDPWR VDPWR sky130_fd_pr__pfet_01v8 ad=0.135 pd=1.27 as=0.26 ps=2.52 w=1 l=0.15
X58 sky130_hd_ro37_nand_0.sky130_hd_inv_1_18.Y sky130_hd_ro37_nand_0.sky130_hd_inv_1_19.Y uo_out[7] uo_out[7] sky130_fd_pr__nfet_01v8 ad=0.0878 pd=0.92 as=0.169 ps=1.82 w=0.65 l=0.15
X59 sky130_hd_ro41_nand_0.sky130_hd_inv_1_35.Y sky130_hd_ro41_nand_0.sky130_hd_inv_1_36.Y VDPWR VDPWR sky130_fd_pr__pfet_01v8 ad=0.135 pd=1.27 as=0.26 ps=2.52 w=1 l=0.15
X60 a_22441_35929# a_22194_35563# VDPWR VDPWR sky130_fd_pr__pfet_01v8_hvt ad=0.0767 pd=0.785 as=0.179 ps=1.26 w=0.42 l=0.15
X61 VDPWR sky130_hd_xor_block_3.XORB sky130_hd_xor_block_3.sky130_hd_inv_1_1.Y VDPWR sky130_fd_pr__pfet_01v8 ad=0.26 pd=2.52 as=0.135 ps=1.27 w=1 l=0.15
X62 sky130_hd_ro41_nand_0.sky130_hd_inv_1_35.Y sky130_hd_ro41_nand_0.sky130_hd_inv_1_36.Y uo_out[7] uo_out[7] sky130_fd_pr__nfet_01v8 ad=0.0878 pd=0.92 as=0.169 ps=1.82 w=0.65 l=0.15
X63 sky130_hd_ro47_nand_0.sky130_hd_inv_1_30.Y sky130_hd_ro47_nand_0.sky130_hd_inv_1_31.Y VDPWR VDPWR sky130_fd_pr__pfet_01v8 ad=0.135 pd=1.27 as=0.26 ps=2.52 w=1 l=0.15
X64 sky130_hd_ro47_nand_0.sky130_hd_inv_1_10.A sky130_hd_ro47_nand_0.sky130_hd_inv_1_9.A VDPWR VDPWR sky130_fd_pr__pfet_01v8 ad=0.135 pd=1.27 as=0.26 ps=2.52 w=1 l=0.15
X65 sky130_hd_ro53_nand_0.sky130_hd_inv_1_26.Y sky130_hd_ro53_nand_0.sky130_hd_inv_1_27.Y VDPWR VDPWR sky130_fd_pr__pfet_01v8 ad=0.135 pd=1.27 as=0.26 ps=2.52 w=1 l=0.15
X66 uo_out[7] a_28188_1565# a_28195_1469# uo_out[7] sky130_fd_pr__nfet_01v8 ad=0.0567 pd=0.69 as=0.109 ps=1.36 w=0.42 l=0.15
X67 a_27746_2979# sky130_hd_div_by_2_3.Qb uo_out[7] uo_out[7] sky130_fd_pr__nfet_01v8 ad=0.0813 pd=0.83 as=0.109 ps=1.36 w=0.42 l=0.15
X68 a_24506_35929# a_24259_35563# VDPWR VDPWR sky130_fd_pr__pfet_01v8_hvt ad=0.0767 pd=0.785 as=0.179 ps=1.26 w=0.42 l=0.15
X69 sky130_hd_ro37_nand_0.sky130_hd_inv_1_8.Y sky130_hd_ro37_nand_0.sky130_hd_inv_1_9.Y VDPWR VDPWR sky130_fd_pr__pfet_01v8 ad=0.135 pd=1.27 as=0.26 ps=2.52 w=1 l=0.15
X70 a_27957_1891# a_27558_1891# a_27831_2257# uo_out[7] sky130_fd_pr__special_nfet_01v8 ad=0.0696 pd=0.765 as=0.0621 ps=0.705 w=0.36 l=0.15
X71 sky130_hd_ro33_nand_0.sky130_hd_inv_1_20.Y sky130_hd_ro33_nand_0.sky130_hd_inv_1_21.Y VDPWR VDPWR sky130_fd_pr__pfet_01v8 ad=0.135 pd=1.27 as=0.26 ps=2.52 w=1 l=0.15
X72 VDPWR sky130_hd_ro32_nand_0.sky130_hd_inv_1_28.Y sky130_hd_ro32_nand_0.sky130_hd_inv_1_27.Y VDPWR sky130_fd_pr__pfet_01v8 ad=0.26 pd=2.52 as=0.135 ps=1.27 w=1 l=0.15
X73 sky130_hd_ro47_nand_0.sky130_hd_inv_1_29.Y sky130_hd_ro47_nand_0.sky130_hd_inv_1_30.Y uo_out[7] uo_out[7] sky130_fd_pr__nfet_01v8 ad=0.0878 pd=0.92 as=0.169 ps=1.82 w=0.65 l=0.15
X74 sky130_hd_ro41_nand_0.sky130_hd_inv_1_4.A sky130_hd_ro41_nand_0.sky130_hd_inv_1_3.A VDPWR VDPWR sky130_fd_pr__pfet_01v8 ad=0.135 pd=1.27 as=0.26 ps=2.52 w=1 l=0.15
X75 sky130_hd_ro41_nand_0.sky130_hd_inv_1_4.A sky130_hd_ro41_nand_0.sky130_hd_inv_1_3.A uo_out[7] uo_out[7] sky130_fd_pr__nfet_01v8 ad=0.0878 pd=0.92 as=0.169 ps=1.82 w=0.65 l=0.15
X76 uo_out[7] sky130_hd_ro32_nand_0.sky130_hd_inv_1_18.Y sky130_hd_ro32_nand_0.sky130_hd_inv_1_17.Y uo_out[7] sky130_fd_pr__nfet_01v8 ad=0.169 pd=1.82 as=0.0878 ps=0.92 w=0.65 l=0.15
X77 a_22265_35537# a_22058_35537# a_22441_35929# VDPWR sky130_fd_pr__pfet_01v8_hvt ad=0.0683 pd=0.745 as=0.0767 ps=0.785 w=0.42 l=0.15
X78 sky130_hd_ro33_nand_0.sky130_hd_inv_1_24.Y sky130_hd_ro33_nand_0.sky130_hd_inv_1_25.Y VDPWR VDPWR sky130_fd_pr__pfet_01v8 ad=0.135 pd=1.27 as=0.26 ps=2.52 w=1 l=0.15
X79 VDPWR sky130_hd_ro33_nand_0.sky130_hd_inv_1_5.Y sky130_hd_ro33_nand_0.sky130_hd_inv_1_4.Y VDPWR sky130_fd_pr__pfet_01v8 ad=0.26 pd=2.52 as=0.135 ps=1.27 w=1 l=0.15
X80 a_23186_31740# sky130_hd_xor_block_1.sky130_hd_xor2_1_0.A uo_out[7] uo_out[7] sky130_fd_pr__nfet_01v8 ad=0.0878 pd=0.92 as=0.0878 ps=0.92 w=0.65 l=0.15
X81 VDPWR sky130_hd_ro41_nand_0.sky130_hd_inv_1_19.Y sky130_hd_ro41_nand_0.sky130_hd_inv_1_18.Y VDPWR sky130_fd_pr__pfet_01v8 ad=0.26 pd=2.52 as=0.135 ps=1.27 w=1 l=0.15
X82 uo_out[7] sky130_hd_ro47_nand_0.sky130_hd_inv_1_16.A sky130_hd_ro47_nand_0.sky130_hd_inv_1_16.Y uo_out[7] sky130_fd_pr__nfet_01v8 ad=0.169 pd=1.82 as=0.0878 ps=0.92 w=0.65 l=0.15
X83 VDPWR a_27631_2762# sky130_hd_div_by_2_2.Q VDPWR sky130_fd_pr__pfet_01v8_hvt ad=0.135 pd=1.27 as=0.26 ps=2.52 w=1 l=0.15
X84 uo_out[7] a_28395_1624# a_28324_1725# uo_out[7] sky130_fd_pr__nfet_01v8 ad=0.121 pd=1.09 as=0.0989 ps=0.995 w=0.64 l=0.15
X85 a_24330_35537# a_24123_35537# a_24506_35929# VDPWR sky130_fd_pr__pfet_01v8_hvt ad=0.0683 pd=0.745 as=0.0767 ps=0.785 w=0.42 l=0.15
X86 uo_out[7] sky130_hd_ro41_nand_0.sky130_hd_inv_1_19.Y sky130_hd_ro41_nand_0.sky130_hd_inv_1_18.Y uo_out[7] sky130_fd_pr__nfet_01v8 ad=0.169 pd=1.82 as=0.0878 ps=0.92 w=0.65 l=0.15
X87 VDPWR sky130_hd_ro32_nand_0.sky130_hd_inv_1_25.Y sky130_hd_ro32_nand_0.sky130_hd_inv_1_24.Y VDPWR sky130_fd_pr__pfet_01v8 ad=0.26 pd=2.52 as=0.135 ps=1.27 w=1 l=0.15
X88 a_24259_35563# a_24123_35537# a_23839_35537# VDPWR sky130_fd_pr__pfet_01v8_hvt ad=0.109 pd=1.08 as=0.0567 ps=0.69 w=0.42 l=0.15
X89 sky130_hd_ro37_nand_0.sky130_hd_inv_1_32.Y sky130_hd_ro37_nand_0.sky130_hd_inv_1_33.Y VDPWR VDPWR sky130_fd_pr__pfet_01v8 ad=0.135 pd=1.27 as=0.26 ps=2.52 w=1 l=0.15
X90 a_27746_1891# sky130_hd_div_by_2_0.Qb uo_out[7] uo_out[7] sky130_fd_pr__nfet_01v8 ad=0.0813 pd=0.83 as=0.109 ps=1.36 w=0.42 l=0.15
X91 uo_out[7] sky130_hd_ro53_nand_0.sky130_hd_inv_1_1.Y sky130_hd_xor_block_0.XORB uo_out[7] sky130_fd_pr__nfet_01v8 ad=0.169 pd=1.82 as=0.0878 ps=0.92 w=0.65 l=0.15
X92 uo_out[7] a_19445_33932# sky130_hd_xor_block_3.XOROUT uo_out[7] sky130_fd_pr__nfet_01v8 ad=0.208 pd=1.94 as=0.25 ps=1.42 w=0.65 l=0.15
X93 sky130_hd_ro37_nand_0.sky130_hd_inv_1_30.Y sky130_hd_ro37_nand_0.sky130_hd_inv_1_31.Y uo_out[7] uo_out[7] sky130_fd_pr__nfet_01v8 ad=0.0878 pd=0.92 as=0.169 ps=1.82 w=0.65 l=0.15
X94 sky130_hd_ro32_nand_0.sky130_hd_inv_1_27.Y sky130_hd_ro32_nand_0.sky130_hd_inv_1_28.Y uo_out[7] uo_out[7] sky130_fd_pr__nfet_01v8 ad=0.0878 pd=0.92 as=0.169 ps=1.82 w=0.65 l=0.15
X95 sky130_hd_ro53_nand_0.sky130_hd_inv_1_38.Y sky130_hd_ro53_nand_0.sky130_hd_inv_1_39.Y uo_out[7] uo_out[7] sky130_fd_pr__nfet_01v8 ad=0.0878 pd=0.92 as=0.169 ps=1.82 w=0.65 l=0.15
X96 sky130_hd_ro41_nand_0.sky130_hd_inv_1_29.Y sky130_hd_ro41_nand_0.sky130_hd_inv_1_29.A VDPWR VDPWR sky130_fd_pr__pfet_01v8 ad=0.135 pd=1.27 as=0.26 ps=2.52 w=1 l=0.15
X97 sky130_hd_ro47_nand_0.sky130_hd_inv_1_38.Y sky130_hd_ro47_nand_0.sky130_hd_inv_1_39.Y VDPWR VDPWR sky130_fd_pr__pfet_01v8 ad=0.135 pd=1.27 as=0.26 ps=2.52 w=1 l=0.15
X98 VDPWR sky130_hd_ro47_nand_0.sky130_hd_inv_1_11.A sky130_hd_ro47_nand_0.sky130_hd_inv_1_12.A VDPWR sky130_fd_pr__pfet_01v8 ad=0.26 pd=2.52 as=0.135 ps=1.27 w=1 l=0.15
X99 uo_out[7] sky130_hd_ro32_nand_0.sky130_hd_inv_1_15.Y sky130_hd_ro32_nand_0.sky130_hd_inv_1_14.Y uo_out[7] sky130_fd_pr__nfet_01v8 ad=0.169 pd=1.82 as=0.0878 ps=0.92 w=0.65 l=0.15
X100 uo_out[7] sky130_hd_xor_block_2.XORB sky130_hd_xor_block_2.sky130_hd_inv_1_1.Y uo_out[7] sky130_fd_pr__nfet_01v8 ad=0.169 pd=1.82 as=0.0878 ps=0.92 w=0.65 l=0.15
X101 sky130_hd_ro41_nand_0.sky130_hd_inv_1_29.Y sky130_hd_ro41_nand_0.sky130_hd_inv_1_29.A uo_out[7] uo_out[7] sky130_fd_pr__nfet_01v8 ad=0.0878 pd=0.92 as=0.169 ps=1.82 w=0.65 l=0.15
X102 VDPWR sky130_hd_ro32_nand_0.sky130_hd_inv_1_22.Y sky130_hd_ro32_nand_0.sky130_hd_inv_1_21.Y VDPWR sky130_fd_pr__pfet_01v8 ad=0.26 pd=2.52 as=0.135 ps=1.27 w=1 l=0.15
X103 sky130_hd_ro37_nand_0.sky130_hd_inv_1_17.Y sky130_hd_ro37_nand_0.sky130_hd_inv_1_18.Y VDPWR VDPWR sky130_fd_pr__pfet_01v8 ad=0.135 pd=1.27 as=0.26 ps=2.52 w=1 l=0.15
X104 sky130_hd_ro53_nand_0.sky130_hd_inv_1_39.Y sky130_hd_ro53_nand_0.sky130_hd_inv_1_40.Y VDPWR VDPWR sky130_fd_pr__pfet_01v8 ad=0.135 pd=1.27 as=0.26 ps=2.52 w=1 l=0.15
X105 VDPWR sky130_hd_ro33_nand_0.sky130_hd_inv_1_30.Y sky130_hd_ro33_nand_0.sky130_hd_inv_1_29.Y VDPWR sky130_fd_pr__pfet_01v8 ad=0.26 pd=2.52 as=0.135 ps=1.27 w=1 l=0.15
X106 sky130_hd_ro41_nand_0.sky130_hd_inv_1_32.Y sky130_hd_ro41_nand_0.sky130_hd_inv_1_33.Y VDPWR VDPWR sky130_fd_pr__pfet_01v8 ad=0.135 pd=1.27 as=0.26 ps=2.52 w=1 l=0.15
X107 sky130_hd_ro41_nand_0.sky130_hd_inv_1_32.Y sky130_hd_ro41_nand_0.sky130_hd_inv_1_33.Y uo_out[7] uo_out[7] sky130_fd_pr__nfet_01v8 ad=0.0878 pd=0.92 as=0.169 ps=1.82 w=0.65 l=0.15
X108 VDPWR sky130_hd_ro47_nand_0.sky130_hd_inv_1_7.A sky130_hd_ro47_nand_0.sky130_hd_inv_1_8.A VDPWR sky130_fd_pr__pfet_01v8 ad=0.26 pd=2.52 as=0.135 ps=1.27 w=1 l=0.15
X109 sky130_hd_ro32_nand_0.sky130_hd_inv_1_24.Y sky130_hd_ro32_nand_0.sky130_hd_inv_1_25.Y uo_out[7] uo_out[7] sky130_fd_pr__nfet_01v8 ad=0.0878 pd=0.92 as=0.169 ps=1.82 w=0.65 l=0.15
X110 sky130_hd_ro32_nand_0.sky130_hd_inv_1_30.Y sky130_hd_ro32_nand_0.sky130_hd_inv_1_31.Y VDPWR VDPWR sky130_fd_pr__pfet_01v8 ad=0.135 pd=1.27 as=0.26 ps=2.52 w=1 l=0.15
X111 sky130_hd_ro47_nand_0.sky130_hd_inv_1_13.A sky130_hd_ro47_nand_0.sky130_hd_inv_1_12.A VDPWR VDPWR sky130_fd_pr__pfet_01v8 ad=0.135 pd=1.27 as=0.26 ps=2.52 w=1 l=0.15
X112 sky130_hd_ro53_nand_0.sky130_hd_inv_1_13.A sky130_hd_ro53_nand_0.sky130_hd_inv_1_24.Y VDPWR VDPWR sky130_fd_pr__pfet_01v8 ad=0.135 pd=1.27 as=0.26 ps=2.52 w=1 l=0.15
X113 sky130_hd_ro37_nand_0.sky130_hd_inv_1_35.Y sky130_hd_ro37_nand_0.sky130_hd_nand2_1_0.Y uo_out[7] uo_out[7] sky130_fd_pr__nfet_01v8 ad=0.0878 pd=0.92 as=0.169 ps=1.82 w=0.65 l=0.15
X114 VDPWR sky130_hd_ro32_nand_0.sky130_hd_inv_1_19.Y sky130_hd_ro32_nand_0.sky130_hd_inv_1_18.Y VDPWR sky130_fd_pr__pfet_01v8 ad=0.26 pd=2.52 as=0.135 ps=1.27 w=1 l=0.15
X115 VDPWR sky130_hd_ro41_nand_0.sky130_hd_inv_1_28.Y sky130_hd_ro41_nand_0.sky130_hd_inv_1_27.Y VDPWR sky130_fd_pr__pfet_01v8 ad=0.26 pd=2.52 as=0.135 ps=1.27 w=1 l=0.15
X116 uo_out[7] sky130_hd_ro41_nand_0.sky130_hd_inv_1_28.Y sky130_hd_ro41_nand_0.sky130_hd_inv_1_27.Y uo_out[7] sky130_fd_pr__nfet_01v8 ad=0.169 pd=1.82 as=0.0878 ps=0.92 w=0.65 l=0.15
X117 VDPWR sky130_hd_ro47_nand_0.sky130_hd_inv_1_21.Y sky130_hd_ro47_nand_0.sky130_hd_inv_1_20.Y VDPWR sky130_fd_pr__pfet_01v8 ad=0.26 pd=2.52 as=0.135 ps=1.27 w=1 l=0.15
X118 sky130_hd_ro47_nand_0.sky130_hd_inv_1_14.A sky130_hd_ro47_nand_0.sky130_hd_inv_1_13.A uo_out[7] uo_out[7] sky130_fd_pr__nfet_01v8 ad=0.0878 pd=0.92 as=0.169 ps=1.82 w=0.65 l=0.15
X119 a_27999_3091# a_27831_3345# VDPWR VDPWR sky130_fd_pr__pfet_01v8_hvt ad=0.109 pd=1.08 as=0.179 ps=1.26 w=0.75 l=0.15
X120 sky130_hd_ro32_nand_0.sky130_hd_inv_1_21.Y sky130_hd_ro32_nand_0.sky130_hd_inv_1_22.Y uo_out[7] uo_out[7] sky130_fd_pr__nfet_01v8 ad=0.0878 pd=0.92 as=0.169 ps=1.82 w=0.65 l=0.15
X121 uo_out[7] sky130_hd_ro33_nand_0.sky130_hd_inv_1_11.Y sky130_hd_ro33_nand_0.sky130_hd_inv_1_10.Y uo_out[7] sky130_fd_pr__nfet_01v8 ad=0.169 pd=1.82 as=0.0878 ps=0.92 w=0.65 l=0.15
X122 sky130_hd_xor_block_3.XORA sky130_hd_ro33_nand_0.sky130_hd_inv_1_1.Y uo_out[7] uo_out[7] sky130_fd_pr__nfet_01v8 ad=0.0878 pd=0.92 as=0.169 ps=1.82 w=0.65 l=0.15
X123 sky130_hd_ro53_nand_0.sky130_hd_inv_1_46.Y sky130_hd_ro53_nand_0.sky130_hd_inv_1_47.Y uo_out[7] uo_out[7] sky130_fd_pr__nfet_01v8 ad=0.0878 pd=0.92 as=0.169 ps=1.82 w=0.65 l=0.15
X124 VDPWR sky130_hd_ro33_nand_0.sky130_hd_inv_1_2.Y sky130_hd_ro33_nand_0.sky130_hd_inv_1_1.Y VDPWR sky130_fd_pr__pfet_01v8 ad=0.26 pd=2.52 as=0.135 ps=1.27 w=1 l=0.15
X125 sky130_hd_xor_block_1.sky130_hd_inv_1_3.A sky130_hd_xor_block_2.XOROUT uo_out[7] uo_out[7] sky130_fd_pr__nfet_01v8 ad=0.0878 pd=0.92 as=0.169 ps=1.82 w=0.65 l=0.15
X126 VDPWR sky130_hd_ro53_nand_0.sky130_hd_inv_1_38.Y sky130_hd_ro53_nand_0.sky130_hd_inv_1_37.Y VDPWR sky130_fd_pr__pfet_01v8 ad=0.26 pd=2.52 as=0.135 ps=1.27 w=1 l=0.15
X127 a_28395_2712# a_28188_2653# a_28571_2435# VDPWR sky130_fd_pr__pfet_01v8_hvt ad=0.0683 pd=0.745 as=0.0767 ps=0.785 w=0.42 l=0.15
X128 uo_out[7] sky130_hd_inv_4_0.A uo_out[0] uo_out[7] sky130_fd_pr__nfet_01v8 ad=0.0878 pd=0.92 as=0.0878 ps=0.92 w=0.65 l=0.15
X129 VDPWR sky130_hd_ro37_nand_0.sky130_hd_inv_1_4.A sky130_hd_ro37_nand_0.sky130_hd_inv_1_5.A VDPWR sky130_fd_pr__pfet_01v8 ad=0.26 pd=2.52 as=0.135 ps=1.27 w=1 l=0.15
X130 uo_out[7] sky130_hd_ro37_nand_0.sky130_hd_inv_1_3.A sky130_hd_ro37_nand_0.sky130_hd_inv_1_4.A uo_out[7] sky130_fd_pr__nfet_01v8 ad=0.169 pd=1.82 as=0.0878 ps=0.92 w=0.65 l=0.15
X131 sky130_hd_ro47_nand_0.sky130_hd_inv_1_39.Y sky130_hd_ro47_nand_0.sky130_hd_inv_1_40.Y uo_out[7] uo_out[7] sky130_fd_pr__nfet_01v8 ad=0.0878 pd=0.92 as=0.169 ps=1.82 w=0.65 l=0.15
X132 a_22612_35563# a_22058_35537# a_22265_35537# uo_out[7] sky130_fd_pr__special_nfet_01v8 ad=0.0813 pd=0.83 as=0.0621 ps=0.705 w=0.36 l=0.15
X133 sky130_hd_ro37_nand_0.sky130_hd_inv_1_29.Y sky130_hd_ro37_nand_0.sky130_hd_inv_1_30.Y VDPWR VDPWR sky130_fd_pr__pfet_01v8 ad=0.135 pd=1.27 as=0.26 ps=2.52 w=1 l=0.15
X134 uo_out[7] a_27536_3497# sky130_hd_div_by_2_4.Qb uo_out[7] sky130_fd_pr__nfet_01v8 ad=0.097 pd=0.975 as=0.169 ps=1.82 w=0.65 l=0.15
X135 sky130_hd_ro53_nand_0.sky130_hd_inv_1_35.Y sky130_hd_ro53_nand_0.sky130_hd_inv_1_36.Y uo_out[7] uo_out[7] sky130_fd_pr__nfet_01v8 ad=0.0878 pd=0.92 as=0.169 ps=1.82 w=0.65 l=0.15
X136 a_27999_2003# a_27831_2257# VDPWR VDPWR sky130_fd_pr__pfet_01v8_hvt ad=0.109 pd=1.08 as=0.179 ps=1.26 w=0.75 l=0.15
X137 a_28571_2435# a_28324_2813# VDPWR VDPWR sky130_fd_pr__pfet_01v8_hvt ad=0.0767 pd=0.785 as=0.179 ps=1.26 w=0.42 l=0.15
X138 a_27903_1579# a_28195_1469# a_28146_1347# VDPWR sky130_fd_pr__pfet_01v8_hvt ad=0.0567 pd=0.69 as=0.0882 ps=0.84 w=0.42 l=0.15
X139 sky130_hd_ro33_nand_0.sky130_hd_inv_1_26.Y sky130_hd_ro33_nand_0.sky130_hd_inv_1_27.Y VDPWR VDPWR sky130_fd_pr__pfet_01v8 ad=0.135 pd=1.27 as=0.26 ps=2.52 w=1 l=0.15
X140 uo_out[7] sky130_hd_ro33_nand_0.sky130_hd_inv_1_29.Y sky130_hd_ro33_nand_0.sky130_hd_inv_1_28.Y uo_out[7] sky130_fd_pr__nfet_01v8 ad=0.169 pd=1.82 as=0.0878 ps=0.92 w=0.65 l=0.15
X141 a_27631_1674# a_27903_1579# VDPWR VDPWR sky130_fd_pr__pfet_01v8_hvt ad=0.27 pd=2.54 as=0.135 ps=1.27 w=1 l=0.15
X142 uo_out[7] sky130_hd_ro53_nand_0.sky130_hd_inv_1_3.Y sky130_hd_ro53_nand_0.sky130_hd_inv_1_2.Y uo_out[7] sky130_fd_pr__nfet_01v8 ad=0.169 pd=1.82 as=0.0878 ps=0.92 w=0.65 l=0.15
X143 a_28395_2712# a_28195_2557# a_28544_2801# uo_out[7] sky130_fd_pr__special_nfet_01v8 ad=0.0621 pd=0.705 as=0.0696 ps=0.765 w=0.36 l=0.15
X144 VDPWR sky130_hd_ro37_nand_0.sky130_hd_inv_1_28.Y sky130_hd_ro37_nand_0.sky130_hd_inv_1_27.Y VDPWR sky130_fd_pr__pfet_01v8 ad=0.26 pd=2.52 as=0.135 ps=1.27 w=1 l=0.15
X145 VDPWR sky130_hd_ro47_nand_0.sky130_hd_inv_1_18.Y sky130_hd_ro47_nand_0.sky130_hd_inv_1_7.A VDPWR sky130_fd_pr__pfet_01v8 ad=0.26 pd=2.52 as=0.135 ps=1.27 w=1 l=0.15
X146 sky130_hd_ro33_nand_0.sky130_hd_inv_1_4.Y sky130_hd_ro33_nand_0.sky130_hd_inv_1_5.Y VDPWR VDPWR sky130_fd_pr__pfet_01v8 ad=0.135 pd=1.27 as=0.26 ps=2.52 w=1 l=0.15
X147 sky130_hd_ro41_nand_0.sky130_hd_inv_1_18.Y sky130_hd_ro41_nand_0.sky130_hd_inv_1_19.Y VDPWR VDPWR sky130_fd_pr__pfet_01v8 ad=0.135 pd=1.27 as=0.26 ps=2.52 w=1 l=0.15
X148 sky130_hd_ro47_nand_0.sky130_hd_inv_1_16.Y sky130_hd_ro47_nand_0.sky130_hd_inv_1_16.A uo_out[7] uo_out[7] sky130_fd_pr__nfet_01v8 ad=0.0878 pd=0.92 as=0.169 ps=1.82 w=0.65 l=0.15
X149 a_28256_3345# a_27392_2979# a_27999_3091# VDPWR sky130_fd_pr__pfet_01v8_hvt ad=0.0567 pd=0.69 as=0.109 ps=1.08 w=0.42 l=0.15
X150 uo_out[7] a_22936_31990# sky130_hd_xor_block_1.XOROUT uo_out[7] sky130_fd_pr__nfet_01v8 ad=0.208 pd=1.94 as=0.25 ps=1.42 w=0.65 l=0.15
X151 sky130_hd_ro41_nand_0.sky130_hd_inv_1_18.Y sky130_hd_ro41_nand_0.sky130_hd_inv_1_19.Y uo_out[7] uo_out[7] sky130_fd_pr__nfet_01v8 ad=0.0878 pd=0.92 as=0.169 ps=1.82 w=0.65 l=0.15
X152 uo_out[7] sky130_hd_ro53_nand_0.sky130_hd_inv_1_18.A sky130_hd_ro53_nand_0.sky130_hd_inv_1_19.A uo_out[7] sky130_fd_pr__nfet_01v8 ad=0.169 pd=1.82 as=0.0878 ps=0.92 w=0.65 l=0.15
X153 uo_out[7] sky130_hd_ro37_nand_0.sky130_hd_inv_1_6.A sky130_hd_xor_block_3.XORB uo_out[7] sky130_fd_pr__nfet_01v8 ad=0.169 pd=1.82 as=0.0878 ps=0.92 w=0.65 l=0.15
X154 VDPWR sky130_hd_ro53_nand_0.sky130_hd_inv_1_35.Y sky130_hd_ro53_nand_0.sky130_hd_inv_1_34.Y VDPWR sky130_fd_pr__pfet_01v8 ad=0.26 pd=2.52 as=0.135 ps=1.27 w=1 l=0.15
X155 VDPWR sky130_hd_ro53_nand_0.sky130_hd_inv_1_17.A sky130_hd_ro53_nand_0.sky130_hd_inv_1_18.A VDPWR sky130_fd_pr__pfet_01v8 ad=0.26 pd=2.52 as=0.135 ps=1.27 w=1 l=0.15
X156 a_2975_25393# ui_in[7] uo_out[7] uo_out[7] sky130_fd_pr__nfet_01v8 ad=0.0878 pd=0.92 as=0.169 ps=1.82 w=0.65 l=0.15
X157 VDPWR sky130_hd_ro37_nand_0.sky130_hd_inv_1_17.Y sky130_hd_ro37_nand_0.sky130_hd_inv_1_16.Y VDPWR sky130_fd_pr__pfet_01v8 ad=0.26 pd=2.52 as=0.135 ps=1.27 w=1 l=0.15
X158 sky130_hd_ro47_nand_0.sky130_hd_inv_1_12.A sky130_hd_ro47_nand_0.sky130_hd_inv_1_11.A VDPWR VDPWR sky130_fd_pr__pfet_01v8 ad=0.135 pd=1.27 as=0.26 ps=2.52 w=1 l=0.15
X159 sky130_hd_ro53_nand_0.sky130_hd_inv_1_7.Y sky130_hd_ro53_nand_0.sky130_hd_inv_1_8.Y VDPWR VDPWR sky130_fd_pr__pfet_01v8 ad=0.135 pd=1.27 as=0.26 ps=2.52 w=1 l=0.15
X160 a_28742_2813# a_28188_2653# a_28395_2712# uo_out[7] sky130_fd_pr__special_nfet_01v8 ad=0.0813 pd=0.83 as=0.0621 ps=0.705 w=0.36 l=0.15
X161 VDPWR sky130_hd_ro32_nand_0.sky130_hd_inv_1_8.Y sky130_hd_ro32_nand_0.sky130_hd_inv_1_7.Y VDPWR sky130_fd_pr__pfet_01v8 ad=0.26 pd=2.52 as=0.135 ps=1.27 w=1 l=0.15
X162 uo_out[7] sky130_hd_ro53_nand_0.sky130_hd_inv_1_14.A sky130_hd_ro53_nand_0.sky130_hd_inv_1_15.A uo_out[7] sky130_fd_pr__nfet_01v8 ad=0.169 pd=1.82 as=0.0878 ps=0.92 w=0.65 l=0.15
X163 uo_out[7] sky130_hd_inv_4_0.A uo_out[0] uo_out[7] sky130_fd_pr__nfet_01v8 ad=0.169 pd=1.82 as=0.0878 ps=0.92 w=0.65 l=0.15
X164 sky130_hd_xor_block_2.sky130_hd_xor2_1_0.B sky130_hd_xor_block_2.sky130_hd_inv_1_3.A VDPWR VDPWR sky130_fd_pr__pfet_01v8 ad=0.135 pd=1.27 as=0.26 ps=2.52 w=1 l=0.15
X165 VDPWR sky130_hd_ro47_nand_0.sky130_hd_inv_1_23.Y sky130_hd_ro47_nand_0.sky130_hd_inv_1_22.Y VDPWR sky130_fd_pr__pfet_01v8 ad=0.26 pd=2.52 as=0.135 ps=1.27 w=1 l=0.15
X166 uo_out[7] sky130_hd_ro37_nand_0.sky130_hd_inv_1_2.A sky130_hd_ro37_nand_0.sky130_hd_inv_1_3.A uo_out[7] sky130_fd_pr__nfet_01v8 ad=0.169 pd=1.82 as=0.0878 ps=0.92 w=0.65 l=0.15
X167 VDPWR sky130_hd_ro53_nand_0.sky130_hd_inv_1_13.A sky130_hd_ro53_nand_0.sky130_hd_inv_1_14.A VDPWR sky130_fd_pr__pfet_01v8 ad=0.26 pd=2.52 as=0.135 ps=1.27 w=1 l=0.15
X168 uo_out[7] sky130_hd_xor_block_3.XORA sky130_hd_xor_block_3.sky130_hd_inv_1_3.A uo_out[7] sky130_fd_pr__nfet_01v8 ad=0.169 pd=1.82 as=0.0878 ps=0.92 w=0.65 l=0.15
X169 sky130_hd_ro32_nand_0.sky130_hd_inv_1_10.Y sky130_hd_ro32_nand_0.sky130_hd_inv_1_11.Y uo_out[7] uo_out[7] sky130_fd_pr__nfet_01v8 ad=0.0878 pd=0.92 as=0.169 ps=1.82 w=0.65 l=0.15
X170 VDPWR sky130_hd_ro41_nand_0.sky130_hd_inv_1_17.Y sky130_hd_ro41_nand_0.sky130_hd_inv_1_16.Y VDPWR sky130_fd_pr__pfet_01v8 ad=0.26 pd=2.52 as=0.135 ps=1.27 w=1 l=0.15
X171 sky130_hd_ro47_nand_0.sky130_hd_inv_1_25.Y sky130_hd_ro47_nand_0.sky130_hd_inv_1_26.Y uo_out[7] uo_out[7] sky130_fd_pr__nfet_01v8 ad=0.0878 pd=0.92 as=0.169 ps=1.82 w=0.65 l=0.15
X172 uo_out[7] sky130_hd_ro47_nand_0.sky130_hd_inv_1_5.Y sky130_hd_ro47_nand_0.sky130_hd_inv_1_4.Y uo_out[7] sky130_fd_pr__nfet_01v8 ad=0.169 pd=1.82 as=0.0878 ps=0.92 w=0.65 l=0.15
X173 uo_out[7] sky130_hd_ro53_nand_0.sky130_hd_inv_1_26.Y sky130_hd_ro53_nand_0.sky130_hd_inv_1_25.Y uo_out[7] sky130_fd_pr__nfet_01v8 ad=0.169 pd=1.82 as=0.0878 ps=0.92 w=0.65 l=0.15
X174 uo_out[7] sky130_hd_dfxtp_1_1.Q a_22612_35563# uo_out[7] sky130_fd_pr__nfet_01v8 ad=0.109 pd=1.36 as=0.0813 ps=0.83 w=0.42 l=0.15
X175 uo_out[7] a_24123_35537# a_24130_35837# uo_out[7] sky130_fd_pr__nfet_01v8 ad=0.0567 pd=0.69 as=0.109 ps=1.36 w=0.42 l=0.15
X176 uo_out[7] sky130_hd_ro41_nand_0.sky130_hd_inv_1_17.Y sky130_hd_ro41_nand_0.sky130_hd_inv_1_16.Y uo_out[7] sky130_fd_pr__nfet_01v8 ad=0.169 pd=1.82 as=0.0878 ps=0.92 w=0.65 l=0.15
X177 VDPWR sky130_hd_ro32_nand_0.sky130_hd_inv_1_5.Y sky130_hd_ro32_nand_0.sky130_hd_inv_1_4.Y VDPWR sky130_fd_pr__pfet_01v8 ad=0.26 pd=2.52 as=0.135 ps=1.27 w=1 l=0.15
X178 VDPWR sky130_hd_xor_block_3.XORA sky130_hd_ro33_nand_0.sky130_hd_nand2_1_0.Y VDPWR sky130_fd_pr__pfet_01v8 ad=0.26 pd=2.52 as=0.135 ps=1.27 w=1 l=0.15
X179 sky130_hd_ro47_nand_0.sky130_hd_inv_1_3.Y sky130_hd_ro47_nand_0.sky130_hd_inv_1_4.Y VDPWR VDPWR sky130_fd_pr__pfet_01v8 ad=0.135 pd=1.27 as=0.26 ps=2.52 w=1 l=0.15
X180 sky130_hd_ro32_nand_0.sky130_hd_inv_1_7.Y sky130_hd_ro32_nand_0.sky130_hd_inv_1_8.Y uo_out[7] uo_out[7] sky130_fd_pr__nfet_01v8 ad=0.0878 pd=0.92 as=0.169 ps=1.82 w=0.65 l=0.15
X181 a_24058_35563# a_23743_35715# uo_out[7] uo_out[7] sky130_fd_pr__nfet_01v8 ad=0.066 pd=0.745 as=0.109 ps=1.36 w=0.42 l=0.15
X182 VDPWR sky130_hd_ro53_nand_0.sky130_hd_inv_1_43.Y sky130_hd_ro53_nand_0.sky130_hd_inv_1_42.Y VDPWR sky130_fd_pr__pfet_01v8 ad=0.26 pd=2.52 as=0.135 ps=1.27 w=1 l=0.15
X183 VDPWR a_28424_3247# a_28340_3345# VDPWR sky130_fd_pr__pfet_01v8_hvt ad=0.111 pd=1.37 as=0.0882 ps=0.84 w=0.42 l=0.15
X184 sky130_hd_ro53_nand_0.sky130_hd_inv_1_16.A sky130_hd_ro53_nand_0.sky130_hd_inv_1_15.A uo_out[7] uo_out[7] sky130_fd_pr__nfet_01v8 ad=0.0878 pd=0.92 as=0.169 ps=1.82 w=0.65 l=0.15
X185 sky130_hd_ro53_nand_0.sky130_hd_inv_1_36.Y sky130_hd_ro53_nand_0.sky130_hd_inv_1_37.Y uo_out[7] uo_out[7] sky130_fd_pr__nfet_01v8 ad=0.0878 pd=0.92 as=0.169 ps=1.82 w=0.65 l=0.15
X186 uo_out[7] sky130_hd_inv_1_0.A sky130_hd_inv_4_0.A uo_out[7] sky130_fd_pr__nfet_01v8 ad=0.169 pd=1.82 as=0.0878 ps=0.92 w=0.65 l=0.15
X187 a_28188_3741# ua[0] uo_out[7] uo_out[7] sky130_fd_pr__nfet_01v8 ad=0.109 pd=1.36 as=0.0567 ps=0.69 w=0.42 l=0.15
X188 sky130_hd_ro32_nand_0.sky130_hd_inv_1_14.Y sky130_hd_ro32_nand_0.sky130_hd_inv_1_15.Y VDPWR VDPWR sky130_fd_pr__pfet_01v8 ad=0.135 pd=1.27 as=0.26 ps=2.52 w=1 l=0.15
X189 sky130_hd_ro33_nand_0.sky130_hd_inv_1_1.Y sky130_hd_ro33_nand_0.sky130_hd_inv_1_2.Y VDPWR VDPWR sky130_fd_pr__pfet_01v8 ad=0.135 pd=1.27 as=0.26 ps=2.52 w=1 l=0.15
X190 VDPWR sky130_hd_ro32_nand_0.sky130_hd_inv_1_2.Y sky130_hd_ro32_nand_0.sky130_hd_inv_1_1.Y VDPWR sky130_fd_pr__pfet_01v8 ad=0.26 pd=2.52 as=0.135 ps=1.27 w=1 l=0.15
X191 sky130_hd_ro33_nand_0.sky130_hd_inv_1_31.Y sky130_hd_ro33_nand_0.sky130_hd_nand2_1_0.Y VDPWR VDPWR sky130_fd_pr__pfet_01v8 ad=0.135 pd=1.27 as=0.26 ps=2.52 w=1 l=0.15
X192 uo_out[7] sky130_hd_ro33_nand_0.sky130_hd_inv_1_4.Y sky130_hd_ro33_nand_0.sky130_hd_inv_1_3.Y uo_out[7] sky130_fd_pr__nfet_01v8 ad=0.169 pd=1.82 as=0.0878 ps=0.92 w=0.65 l=0.15
X193 sky130_hd_ro37_nand_0.sky130_hd_inv_1_5.A sky130_hd_ro37_nand_0.sky130_hd_inv_1_4.A VDPWR VDPWR sky130_fd_pr__pfet_01v8 ad=0.135 pd=1.27 as=0.26 ps=2.52 w=1 l=0.15
X194 uo_out[7] sky130_hd_ro37_nand_0.sky130_hd_inv_1_24.Y sky130_hd_ro37_nand_0.sky130_hd_inv_1_23.Y uo_out[7] sky130_fd_pr__nfet_01v8 ad=0.169 pd=1.82 as=0.0878 ps=0.92 w=0.65 l=0.15
X195 VDPWR sky130_hd_ro47_nand_0.sky130_hd_inv_1_35.A sky130_hd_ro47_nand_0.sky130_hd_inv_1_35.Y VDPWR sky130_fd_pr__pfet_01v8 ad=0.26 pd=2.52 as=0.135 ps=1.27 w=1 l=0.15
X196 VDPWR sky130_hd_ro47_nand_0.sky130_hd_inv_1_8.A sky130_hd_ro47_nand_0.sky130_hd_inv_1_9.A VDPWR sky130_fd_pr__pfet_01v8 ad=0.26 pd=2.52 as=0.135 ps=1.27 w=1 l=0.15
X197 sky130_hd_ro32_nand_0.sky130_hd_inv_1_4.Y sky130_hd_ro32_nand_0.sky130_hd_inv_1_5.Y uo_out[7] uo_out[7] sky130_fd_pr__nfet_01v8 ad=0.0878 pd=0.92 as=0.169 ps=1.82 w=0.65 l=0.15
X198 sky130_hd_ro47_nand_0.sky130_hd_inv_1_15.A sky130_hd_ro47_nand_0.sky130_hd_inv_1_14.A VDPWR VDPWR sky130_fd_pr__pfet_01v8 ad=0.135 pd=1.27 as=0.26 ps=2.52 w=1 l=0.15
X199 VDPWR sky130_hd_ro53_nand_0.sky130_hd_inv_1_20.A sky130_hd_ro53_nand_0.sky130_hd_inv_1_21.A VDPWR sky130_fd_pr__pfet_01v8 ad=0.26 pd=2.52 as=0.135 ps=1.27 w=1 l=0.15
X200 a_28324_1725# a_28195_1469# a_27903_1579# uo_out[7] sky130_fd_pr__special_nfet_01v8 ad=0.0989 pd=0.995 as=0.0684 ps=0.74 w=0.36 l=0.15
X201 sky130_hd_ro32_nand_0.sky130_hd_inv_1_11.Y sky130_hd_ro32_nand_0.sky130_hd_inv_1_12.Y VDPWR VDPWR sky130_fd_pr__pfet_01v8 ad=0.135 pd=1.27 as=0.26 ps=2.52 w=1 l=0.15
X202 VDPWR sky130_hd_ro37_nand_0.sky130_hd_inv_1_14.Y sky130_hd_ro37_nand_0.sky130_hd_inv_1_13.Y VDPWR sky130_fd_pr__pfet_01v8 ad=0.26 pd=2.52 as=0.135 ps=1.27 w=1 l=0.15
X203 uo_out[7] sky130_hd_ro37_nand_0.sky130_hd_inv_1_27.Y sky130_hd_ro37_nand_0.sky130_hd_inv_1_26.Y uo_out[7] sky130_fd_pr__nfet_01v8 ad=0.169 pd=1.82 as=0.0878 ps=0.92 w=0.65 l=0.15
X204 a_28742_3901# a_28195_3645# a_28395_3800# VDPWR sky130_fd_pr__pfet_01v8_hvt ad=0.0578 pd=0.695 as=0.0683 ps=0.745 w=0.42 l=0.15
X205 sky130_hd_ro33_nand_0.sky130_hd_inv_1_15.Y sky130_hd_ro33_nand_0.sky130_hd_inv_1_16.Y VDPWR VDPWR sky130_fd_pr__pfet_01v8 ad=0.135 pd=1.27 as=0.26 ps=2.52 w=1 l=0.15
X206 VDPWR sky130_hd_ro47_nand_0.sky130_hd_inv_1_20.Y sky130_hd_ro47_nand_0.sky130_hd_inv_1_19.Y VDPWR sky130_fd_pr__pfet_01v8 ad=0.26 pd=2.52 as=0.135 ps=1.27 w=1 l=0.15
X207 uo_out[7] sky130_hd_ro33_nand_0.sky130_hd_inv_1_9.Y sky130_hd_ro33_nand_0.sky130_hd_inv_1_8.Y uo_out[7] sky130_fd_pr__nfet_01v8 ad=0.169 pd=1.82 as=0.0878 ps=0.92 w=0.65 l=0.15
X208 VDPWR sky130_hd_ro41_nand_0.sky130_hd_inv_1_14.Y sky130_hd_ro41_nand_0.sky130_hd_inv_1_13.Y VDPWR sky130_fd_pr__pfet_01v8 ad=0.26 pd=2.52 as=0.135 ps=1.27 w=1 l=0.15
X209 uo_out[7] sky130_hd_ro47_nand_0.sky130_hd_inv_1_2.Y sky130_hd_ro47_nand_0.sky130_hd_inv_1_1.Y uo_out[7] sky130_fd_pr__nfet_01v8 ad=0.169 pd=1.82 as=0.0878 ps=0.92 w=0.65 l=0.15
X210 VDPWR sky130_hd_ro32_nand_0.sky130_hd_inv_1_6.Y sky130_hd_ro32_nand_0.sky130_hd_inv_1_5.Y VDPWR sky130_fd_pr__pfet_01v8 ad=0.26 pd=2.52 as=0.135 ps=1.27 w=1 l=0.15
X211 sky130_hd_ro53_nand_0.sky130_hd_inv_1_29.Y sky130_hd_ro53_nand_0.sky130_hd_inv_1_30.Y uo_out[7] uo_out[7] sky130_fd_pr__nfet_01v8 ad=0.0878 pd=0.92 as=0.169 ps=1.82 w=0.65 l=0.15
X212 uo_out[7] sky130_hd_ro41_nand_0.sky130_hd_inv_1_14.Y sky130_hd_ro41_nand_0.sky130_hd_inv_1_13.Y uo_out[7] sky130_fd_pr__nfet_01v8 ad=0.169 pd=1.82 as=0.0878 ps=0.92 w=0.65 l=0.15
X213 VDPWR sky130_hd_ro53_nand_0.sky130_hd_inv_1_15.A sky130_hd_ro53_nand_0.sky130_hd_inv_1_16.A VDPWR sky130_fd_pr__pfet_01v8 ad=0.26 pd=2.52 as=0.135 ps=1.27 w=1 l=0.15
X214 sky130_hd_ro37_nand_0.sky130_hd_inv_1_27.Y sky130_hd_ro37_nand_0.sky130_hd_inv_1_28.Y VDPWR VDPWR sky130_fd_pr__pfet_01v8 ad=0.135 pd=1.27 as=0.26 ps=2.52 w=1 l=0.15
X215 sky130_hd_ro53_nand_0.sky130_hd_inv_1_30.Y sky130_hd_ro53_nand_0.sky130_hd_inv_1_31.Y VDPWR VDPWR sky130_fd_pr__pfet_01v8 ad=0.135 pd=1.27 as=0.26 ps=2.52 w=1 l=0.15
X216 sky130_hd_xor_block_3.sky130_hd_xor2_1_0.A sky130_hd_xor_block_3.sky130_hd_inv_1_1.Y uo_out[7] uo_out[7] sky130_fd_pr__nfet_01v8 ad=0.0878 pd=0.92 as=0.169 ps=1.82 w=0.65 l=0.15
X217 sky130_hd_ro53_nand_0.sky130_hd_inv_1_19.A sky130_hd_ro53_nand_0.sky130_hd_inv_1_18.A uo_out[7] uo_out[7] sky130_fd_pr__nfet_01v8 ad=0.0878 pd=0.92 as=0.169 ps=1.82 w=0.65 l=0.15
X218 sky130_hd_ro53_nand_0.sky130_hd_inv_1_33.Y sky130_hd_ro53_nand_0.sky130_hd_inv_1_34.Y uo_out[7] uo_out[7] sky130_fd_pr__nfet_01v8 ad=0.0878 pd=0.92 as=0.169 ps=1.82 w=0.65 l=0.15
X219 sky130_hd_xor_block_0.XOROUT sky130_hd_xor_block_0.sky130_hd_xor2_1_0.B a_25118_30583# uo_out[7] sky130_fd_pr__nfet_01v8 ad=0.25 pd=1.42 as=0.0878 ps=0.92 w=0.65 l=0.15
X220 uo_out[7] sky130_hd_ro47_nand_0.sky130_hd_inv_1_36.Y sky130_hd_ro47_nand_0.sky130_hd_inv_1_35.A uo_out[7] sky130_fd_pr__nfet_01v8 ad=0.169 pd=1.82 as=0.0878 ps=0.92 w=0.65 l=0.15
X221 VDPWR sky130_hd_ro37_nand_0.sky130_hd_inv_1_1.A sky130_hd_ro37_nand_0.sky130_hd_inv_1_2.A VDPWR sky130_fd_pr__pfet_01v8 ad=0.26 pd=2.52 as=0.135 ps=1.27 w=1 l=0.15
X222 uo_out[7] sky130_hd_ro37_nand_0.sky130_hd_inv_1_21.Y sky130_hd_ro37_nand_0.sky130_hd_inv_1_20.Y uo_out[7] sky130_fd_pr__nfet_01v8 ad=0.169 pd=1.82 as=0.0878 ps=0.92 w=0.65 l=0.15
X223 sky130_hd_xor_block_3.XORB sky130_hd_ro37_nand_0.sky130_hd_inv_1_6.A uo_out[7] uo_out[7] sky130_fd_pr__nfet_01v8 ad=0.0878 pd=0.92 as=0.169 ps=1.82 w=0.65 l=0.15
X224 sky130_hd_ro53_nand_0.sky130_hd_inv_1_34.Y sky130_hd_ro53_nand_0.sky130_hd_inv_1_35.Y VDPWR VDPWR sky130_fd_pr__pfet_01v8 ad=0.135 pd=1.27 as=0.26 ps=2.52 w=1 l=0.15
X225 uo_out[7] sky130_hd_ro53_nand_0.sky130_hd_inv_1_28.Y sky130_hd_ro53_nand_0.sky130_hd_inv_1_27.Y uo_out[7] sky130_fd_pr__nfet_01v8 ad=0.169 pd=1.82 as=0.0878 ps=0.92 w=0.65 l=0.15
X226 VDPWR sky130_hd_ro41_nand_0.sky130_hd_inv_1_38.Y sky130_hd_ro41_nand_0.sky130_hd_inv_1_37.Y VDPWR sky130_fd_pr__pfet_01v8 ad=0.26 pd=2.52 as=0.135 ps=1.27 w=1 l=0.15
X227 sky130_hd_xor_block_0.sky130_hd_inv_1_1.Y sky130_hd_xor_block_0.XORB VDPWR VDPWR sky130_fd_pr__pfet_01v8 ad=0.135 pd=1.27 as=0.26 ps=2.52 w=1 l=0.15
X228 sky130_hd_ro32_nand_0.sky130_hd_inv_1_28.Y sky130_hd_ro32_nand_0.sky130_hd_inv_1_29.Y uo_out[7] uo_out[7] sky130_fd_pr__nfet_01v8 ad=0.0878 pd=0.92 as=0.169 ps=1.82 w=0.65 l=0.15
X229 uo_out[7] sky130_hd_ro41_nand_0.sky130_hd_inv_1_38.Y sky130_hd_ro41_nand_0.sky130_hd_inv_1_37.Y uo_out[7] sky130_fd_pr__nfet_01v8 ad=0.169 pd=1.82 as=0.0878 ps=0.92 w=0.65 l=0.15
X230 uo_out[0] sky130_hd_inv_4_0.A uo_out[7] uo_out[7] sky130_fd_pr__nfet_01v8 ad=0.0878 pd=0.92 as=0.0878 ps=0.92 w=0.65 l=0.15
X231 VDPWR sky130_hd_ro37_nand_0.sky130_hd_inv_1_11.Y sky130_hd_ro37_nand_0.sky130_hd_inv_1_10.Y VDPWR sky130_fd_pr__pfet_01v8 ad=0.26 pd=2.52 as=0.135 ps=1.27 w=1 l=0.15
X232 sky130_hd_ro47_nand_0.sky130_hd_inv_1_5.Y sky130_hd_ro47_nand_0.sky130_hd_inv_1_16.Y VDPWR VDPWR sky130_fd_pr__pfet_01v8 ad=0.135 pd=1.27 as=0.26 ps=2.52 w=1 l=0.15
X233 VDPWR sky130_hd_ro32_nand_0.sky130_hd_inv_1_23.Y sky130_hd_ro32_nand_0.sky130_hd_inv_1_22.Y VDPWR sky130_fd_pr__pfet_01v8 ad=0.26 pd=2.52 as=0.135 ps=1.27 w=1 l=0.15
X234 sky130_hd_ro53_nand_0.sky130_hd_inv_1_47.Y sky130_hd_ro53_nand_0.sky130_hd_inv_1_48.Y VDPWR VDPWR sky130_fd_pr__pfet_01v8 ad=0.135 pd=1.27 as=0.26 ps=2.52 w=1 l=0.15
X235 VDPWR sky130_hd_ro41_nand_0.sky130_hd_inv_1_23.Y sky130_hd_ro41_nand_0.sky130_hd_inv_1_22.Y VDPWR sky130_fd_pr__pfet_01v8 ad=0.26 pd=2.52 as=0.135 ps=1.27 w=1 l=0.15
X236 uo_out[7] sky130_hd_ro41_nand_0.sky130_hd_inv_1_23.Y sky130_hd_ro41_nand_0.sky130_hd_inv_1_22.Y uo_out[7] sky130_fd_pr__nfet_01v8 ad=0.169 pd=1.82 as=0.0878 ps=0.92 w=0.65 l=0.15
X237 sky130_hd_ro47_nand_0.sky130_hd_inv_1_4.Y sky130_hd_ro47_nand_0.sky130_hd_inv_1_5.Y uo_out[7] uo_out[7] sky130_fd_pr__nfet_01v8 ad=0.0878 pd=0.92 as=0.169 ps=1.82 w=0.65 l=0.15
X238 uo_out[7] sky130_hd_ro32_nand_0.sky130_hd_inv_1_16.Y sky130_hd_ro32_nand_0.sky130_hd_inv_1_15.Y uo_out[7] sky130_fd_pr__nfet_01v8 ad=0.169 pd=1.82 as=0.0878 ps=0.92 w=0.65 l=0.15
X239 sky130_hd_ro32_nand_0.sky130_hd_inv_1_25.Y sky130_hd_ro32_nand_0.sky130_hd_inv_1_26.Y uo_out[7] uo_out[7] sky130_fd_pr__nfet_01v8 ad=0.0878 pd=0.92 as=0.169 ps=1.82 w=0.65 l=0.15
X240 uo_out[7] sky130_hd_ro37_nand_0.sky130_hd_inv_1_25.A sky130_hd_ro37_nand_0.sky130_hd_inv_1_25.Y uo_out[7] sky130_fd_pr__nfet_01v8 ad=0.169 pd=1.82 as=0.0878 ps=0.92 w=0.65 l=0.15
X241 VDPWR a_28188_3741# a_28195_3645# VDPWR sky130_fd_pr__pfet_01v8_hvt ad=0.0864 pd=0.91 as=0.166 ps=1.8 w=0.64 l=0.15
X242 uo_out[7] sky130_hd_ro33_nand_0.sky130_hd_inv_1_6.Y sky130_hd_ro33_nand_0.sky130_hd_inv_1_5.Y uo_out[7] sky130_fd_pr__nfet_01v8 ad=0.169 pd=1.82 as=0.0878 ps=0.92 w=0.65 l=0.15
X243 sky130_hd_ro33_nand_0.sky130_hd_nand2_1_0.Y ui_in[3] VDPWR VDPWR sky130_fd_pr__pfet_01v8 ad=0.135 pd=1.27 as=0.26 ps=2.52 w=1 l=0.15
X244 uo_out[7] sky130_hd_ro47_nand_0.sky130_hd_inv_1_45.Y sky130_hd_ro47_nand_0.sky130_hd_inv_1_44.Y uo_out[7] sky130_fd_pr__nfet_01v8 ad=0.169 pd=1.82 as=0.0878 ps=0.92 w=0.65 l=0.15
X245 sky130_hd_ro32_nand_0.sky130_hd_inv_1_31.Y sky130_hd_ro32_nand_0.sky130_hd_nand2_1_0.Y VDPWR VDPWR sky130_fd_pr__pfet_01v8 ad=0.135 pd=1.27 as=0.26 ps=2.52 w=1 l=0.15
X246 uo_out[7] sky130_hd_ro33_nand_0.sky130_hd_inv_1_20.Y sky130_hd_ro33_nand_0.sky130_hd_inv_1_19.Y uo_out[7] sky130_fd_pr__nfet_01v8 ad=0.169 pd=1.82 as=0.0878 ps=0.92 w=0.65 l=0.15
X247 sky130_hd_ro47_nand_0.sky130_hd_inv_1_24.Y sky130_hd_ro47_nand_0.sky130_hd_inv_1_25.Y VDPWR VDPWR sky130_fd_pr__pfet_01v8 ad=0.135 pd=1.27 as=0.26 ps=2.52 w=1 l=0.15
X248 uo_out[7] a_27631_3850# sky130_hd_div_by_2_4.Q uo_out[7] sky130_fd_pr__nfet_01v8 ad=0.0878 pd=0.92 as=0.169 ps=1.82 w=0.65 l=0.15
X249 sky130_hd_ro32_nand_0.sky130_hd_inv_1_29.Y sky130_hd_ro32_nand_0.sky130_hd_inv_1_30.Y VDPWR VDPWR sky130_fd_pr__pfet_01v8 ad=0.135 pd=1.27 as=0.26 ps=2.52 w=1 l=0.15
X250 sky130_hd_ro41_nand_0.sky130_hd_inv_1_7.A sky130_hd_ro41_nand_0.sky130_hd_inv_1_6.A VDPWR VDPWR sky130_fd_pr__pfet_01v8 ad=0.135 pd=1.27 as=0.26 ps=2.52 w=1 l=0.15
X251 sky130_hd_ro53_nand_0.sky130_hd_inv_1_22.A sky130_hd_ro53_nand_0.sky130_hd_inv_1_21.A uo_out[7] uo_out[7] sky130_fd_pr__nfet_01v8 ad=0.0878 pd=0.92 as=0.169 ps=1.82 w=0.65 l=0.15
X252 sky130_hd_ro41_nand_0.sky130_hd_inv_1_7.A sky130_hd_ro41_nand_0.sky130_hd_inv_1_6.A uo_out[7] uo_out[7] sky130_fd_pr__nfet_01v8 ad=0.0878 pd=0.92 as=0.169 ps=1.82 w=0.65 l=0.15
X253 sky130_hd_ro47_nand_0.sky130_hd_inv_1_9.A sky130_hd_ro47_nand_0.sky130_hd_inv_1_8.A VDPWR VDPWR sky130_fd_pr__pfet_01v8 ad=0.135 pd=1.27 as=0.26 ps=2.52 w=1 l=0.15
X254 VDPWR sky130_hd_ro53_nand_0.sky130_hd_inv_1_4.Y sky130_hd_ro53_nand_0.sky130_hd_inv_1_3.Y VDPWR sky130_fd_pr__pfet_01v8 ad=0.26 pd=2.52 as=0.135 ps=1.27 w=1 l=0.15
X255 uo_out[7] sky130_hd_ro37_nand_0.sky130_hd_inv_1_18.Y sky130_hd_ro37_nand_0.sky130_hd_inv_1_17.Y uo_out[7] sky130_fd_pr__nfet_01v8 ad=0.169 pd=1.82 as=0.0878 ps=0.92 w=0.65 l=0.15
X256 VDPWR sky130_hd_div_by_2_2.Qb a_28742_2813# VDPWR sky130_fd_pr__pfet_01v8_hvt ad=0.109 pd=1.36 as=0.0578 ps=0.695 w=0.42 l=0.15
X257 VDPWR a_28188_2653# a_28195_2557# VDPWR sky130_fd_pr__pfet_01v8_hvt ad=0.0864 pd=0.91 as=0.166 ps=1.8 w=0.64 l=0.15
X258 uo_out[7] sky130_hd_ro33_nand_0.sky130_hd_inv_1_24.Y sky130_hd_ro33_nand_0.sky130_hd_inv_1_23.Y uo_out[7] sky130_fd_pr__nfet_01v8 ad=0.169 pd=1.82 as=0.0878 ps=0.92 w=0.65 l=0.15
X259 VDPWR sky130_hd_ro41_nand_0.sky130_hd_inv_1_35.Y sky130_hd_ro41_nand_0.sky130_hd_inv_1_34.Y VDPWR sky130_fd_pr__pfet_01v8 ad=0.26 pd=2.52 as=0.135 ps=1.27 w=1 l=0.15
X260 VDPWR sky130_hd_ro41_nand_0.sky130_hd_inv_1_16.Y sky130_hd_ro41_nand_0.sky130_hd_inv_1_15.Y VDPWR sky130_fd_pr__pfet_01v8 ad=0.26 pd=2.52 as=0.135 ps=1.27 w=1 l=0.15
X261 uo_out[7] sky130_hd_ro41_nand_0.sky130_hd_inv_1_16.Y sky130_hd_ro41_nand_0.sky130_hd_inv_1_15.Y uo_out[7] sky130_fd_pr__nfet_01v8 ad=0.169 pd=1.82 as=0.0878 ps=0.92 w=0.65 l=0.15
X262 sky130_hd_ro47_nand_0.sky130_hd_inv_1_28.Y sky130_hd_ro47_nand_0.sky130_hd_inv_1_29.Y VDPWR VDPWR sky130_fd_pr__pfet_01v8 ad=0.135 pd=1.27 as=0.26 ps=2.52 w=1 l=0.15
X263 sky130_hd_ro41_nand_0.sky130_hd_inv_1_3.A sky130_hd_ro41_nand_0.sky130_hd_inv_1_2.A VDPWR VDPWR sky130_fd_pr__pfet_01v8 ad=0.135 pd=1.27 as=0.26 ps=2.52 w=1 l=0.15
X264 uo_out[7] sky130_hd_ro41_nand_0.sky130_hd_inv_1_35.Y sky130_hd_ro41_nand_0.sky130_hd_inv_1_34.Y uo_out[7] sky130_fd_pr__nfet_01v8 ad=0.169 pd=1.82 as=0.0878 ps=0.92 w=0.65 l=0.15
X265 sky130_hd_ro53_nand_0.sky130_hd_nand2_1_0.Y sky130_hd_xor_block_0.XORB a_2975_25393# uo_out[7] sky130_fd_pr__nfet_01v8 ad=0.169 pd=1.82 as=0.0878 ps=0.92 w=0.65 l=0.15
X266 sky130_hd_ro41_nand_0.sky130_hd_inv_1_3.A sky130_hd_ro41_nand_0.sky130_hd_inv_1_2.A uo_out[7] uo_out[7] sky130_fd_pr__nfet_01v8 ad=0.0878 pd=0.92 as=0.169 ps=1.82 w=0.65 l=0.15
X267 VDPWR sky130_hd_ro53_nand_0.sky130_hd_inv_1_8.Y sky130_hd_ro53_nand_0.sky130_hd_inv_1_7.Y VDPWR sky130_fd_pr__pfet_01v8 ad=0.26 pd=2.52 as=0.135 ps=1.27 w=1 l=0.15
X268 sky130_hd_ro53_nand_0.sky130_hd_inv_1_44.Y sky130_hd_ro53_nand_0.sky130_hd_inv_1_45.Y VDPWR VDPWR sky130_fd_pr__pfet_01v8 ad=0.135 pd=1.27 as=0.26 ps=2.52 w=1 l=0.15
X269 VDPWR a_28395_1624# a_28324_1725# VDPWR sky130_fd_pr__pfet_01v8_hvt ad=0.179 pd=1.26 as=0.109 ps=1.08 w=0.75 l=0.15
X270 sky130_hd_xor_block_3.XOROUT sky130_hd_xor_block_3.sky130_hd_xor2_1_0.B a_19695_33682# uo_out[7] sky130_fd_pr__nfet_01v8 ad=0.25 pd=1.42 as=0.0878 ps=0.92 w=0.65 l=0.15
X271 VDPWR a_27536_2409# sky130_hd_div_by_2_2.Qb VDPWR sky130_fd_pr__pfet_01v8_hvt ad=0.154 pd=1.34 as=0.26 ps=2.52 w=1 l=0.15
X272 sky130_hd_ro53_nand_0.sky130_hd_inv_1_17.A sky130_hd_ro53_nand_0.sky130_hd_inv_1_16.A uo_out[7] uo_out[7] sky130_fd_pr__nfet_01v8 ad=0.0878 pd=0.92 as=0.169 ps=1.82 w=0.65 l=0.15
X273 sky130_hd_ro41_nand_0.sky130_hd_inv_1_13.Y sky130_hd_ro41_nand_0.sky130_hd_inv_1_14.Y VDPWR VDPWR sky130_fd_pr__pfet_01v8 ad=0.135 pd=1.27 as=0.26 ps=2.52 w=1 l=0.15
X274 sky130_hd_ro47_nand_0.sky130_hd_inv_1_1.Y sky130_hd_ro47_nand_0.sky130_hd_inv_1_2.Y uo_out[7] uo_out[7] sky130_fd_pr__nfet_01v8 ad=0.0878 pd=0.92 as=0.169 ps=1.82 w=0.65 l=0.15
X275 sky130_hd_xor_block_3.sky130_hd_inv_1_1.Y sky130_hd_xor_block_3.XORB VDPWR VDPWR sky130_fd_pr__pfet_01v8 ad=0.135 pd=1.27 as=0.26 ps=2.52 w=1 l=0.15
X276 uo_out[7] sky130_hd_ro37_nand_0.sky130_hd_inv_1_23.Y sky130_hd_ro37_nand_0.sky130_hd_inv_1_22.Y uo_out[7] sky130_fd_pr__nfet_01v8 ad=0.169 pd=1.82 as=0.0878 ps=0.92 w=0.65 l=0.15
X277 sky130_hd_ro41_nand_0.sky130_hd_inv_1_13.Y sky130_hd_ro41_nand_0.sky130_hd_inv_1_14.Y uo_out[7] uo_out[7] sky130_fd_pr__nfet_01v8 ad=0.0878 pd=0.92 as=0.169 ps=1.82 w=0.65 l=0.15
X278 a_27558_1891# a_27392_1891# VDPWR VDPWR sky130_fd_pr__pfet_01v8_hvt ad=0.166 pd=1.8 as=0.0864 ps=0.91 w=0.64 l=0.15
X279 uo_out[7] sky130_hd_ro53_nand_0.sky130_hd_inv_1_22.Y sky130_hd_ro53_nand_0.sky130_hd_inv_1_11.Y uo_out[7] sky130_fd_pr__nfet_01v8 ad=0.169 pd=1.82 as=0.0878 ps=0.92 w=0.65 l=0.15
X280 uo_out[7] sky130_hd_ro33_nand_0.sky130_hd_inv_1_3.Y sky130_hd_ro33_nand_0.sky130_hd_inv_1_2.Y uo_out[7] sky130_fd_pr__nfet_01v8 ad=0.169 pd=1.82 as=0.0878 ps=0.92 w=0.65 l=0.15
X281 sky130_hd_xor_block_2.sky130_hd_inv_1_1.Y sky130_hd_xor_block_2.XORB VDPWR VDPWR sky130_fd_pr__pfet_01v8 ad=0.135 pd=1.27 as=0.26 ps=2.52 w=1 l=0.15
X282 sky130_hd_ro37_nand_0.sky130_hd_inv_1_6.A sky130_hd_ro37_nand_0.sky130_hd_inv_1_5.A VDPWR VDPWR sky130_fd_pr__pfet_01v8 ad=0.135 pd=1.27 as=0.26 ps=2.52 w=1 l=0.15
X283 VDPWR sky130_hd_ro41_nand_0.sky130_hd_nand2_1_0.Y sky130_hd_ro41_nand_0.sky130_hd_inv_1_39.Y VDPWR sky130_fd_pr__pfet_01v8 ad=0.26 pd=2.52 as=0.135 ps=1.27 w=1 l=0.15
X284 uo_out[7] sky130_hd_ro41_nand_0.sky130_hd_nand2_1_0.Y sky130_hd_ro41_nand_0.sky130_hd_inv_1_39.Y uo_out[7] sky130_fd_pr__nfet_01v8 ad=0.169 pd=1.82 as=0.0878 ps=0.92 w=0.65 l=0.15
X285 VDPWR sky130_hd_ro47_nand_0.sky130_hd_inv_1_34.Y sky130_hd_ro47_nand_0.sky130_hd_inv_1_33.Y VDPWR sky130_fd_pr__pfet_01v8 ad=0.26 pd=2.52 as=0.135 ps=1.27 w=1 l=0.15
X286 sky130_hd_ro37_nand_0.sky130_hd_inv_1_16.Y sky130_hd_ro37_nand_0.sky130_hd_inv_1_17.Y uo_out[7] uo_out[7] sky130_fd_pr__nfet_01v8 ad=0.0878 pd=0.92 as=0.169 ps=1.82 w=0.65 l=0.15
X287 a_27631_1674# a_27903_1579# uo_out[7] uo_out[7] sky130_fd_pr__nfet_01v8 ad=0.169 pd=1.82 as=0.0878 ps=0.92 w=0.65 l=0.15
X288 VDPWR sky130_hd_ro37_nand_0.sky130_hd_inv_1_12.Y sky130_hd_ro37_nand_0.sky130_hd_inv_1_11.Y VDPWR sky130_fd_pr__pfet_01v8 ad=0.26 pd=2.52 as=0.135 ps=1.27 w=1 l=0.15
X289 uo_out[7] sky130_hd_ro47_nand_0.sky130_hd_inv_1_42.Y sky130_hd_ro47_nand_0.sky130_hd_inv_1_41.Y uo_out[7] sky130_fd_pr__nfet_01v8 ad=0.169 pd=1.82 as=0.0878 ps=0.92 w=0.65 l=0.15
X290 VDPWR sky130_hd_ro53_nand_0.sky130_hd_inv_1_22.A sky130_hd_ro53_nand_0.sky130_hd_inv_1_22.Y VDPWR sky130_fd_pr__pfet_01v8 ad=0.26 pd=2.52 as=0.135 ps=1.27 w=1 l=0.15
X291 a_25118_30583# sky130_hd_xor_block_0.sky130_hd_xor2_1_0.A uo_out[7] uo_out[7] sky130_fd_pr__nfet_01v8 ad=0.0878 pd=0.92 as=0.0878 ps=0.92 w=0.65 l=0.15
X292 sky130_hd_ro47_nand_0.sky130_hd_inv_1_8.A sky130_hd_ro47_nand_0.sky130_hd_inv_1_7.A uo_out[7] uo_out[7] sky130_fd_pr__nfet_01v8 ad=0.0878 pd=0.92 as=0.169 ps=1.82 w=0.65 l=0.15
X293 sky130_hd_ro53_nand_0.sky130_hd_inv_1_49.Y sky130_hd_ro53_nand_0.sky130_hd_inv_1_50.Y VDPWR VDPWR sky130_fd_pr__pfet_01v8 ad=0.135 pd=1.27 as=0.26 ps=2.52 w=1 l=0.15
X294 VDPWR a_21678_35715# sky130_hd_inv_1_0.A VDPWR sky130_fd_pr__pfet_01v8_hvt ad=0.135 pd=1.27 as=0.26 ps=2.52 w=1 l=0.15
X295 sky130_hd_ro37_nand_0.sky130_hd_inv_1_2.A sky130_hd_ro37_nand_0.sky130_hd_inv_1_1.A VDPWR VDPWR sky130_fd_pr__pfet_01v8 ad=0.135 pd=1.27 as=0.26 ps=2.52 w=1 l=0.15
X296 sky130_hd_ro37_nand_0.sky130_hd_inv_1_20.Y sky130_hd_ro37_nand_0.sky130_hd_inv_1_21.Y uo_out[7] uo_out[7] sky130_fd_pr__nfet_01v8 ad=0.0878 pd=0.92 as=0.169 ps=1.82 w=0.65 l=0.15
X297 a_24330_35537# a_24130_35837# a_24479_35563# uo_out[7] sky130_fd_pr__special_nfet_01v8 ad=0.0621 pd=0.705 as=0.0696 ps=0.765 w=0.36 l=0.15
X298 sky130_hd_ro53_nand_0.sky130_hd_inv_1_10.Y sky130_hd_ro53_nand_0.sky130_hd_inv_1_11.Y uo_out[7] uo_out[7] sky130_fd_pr__nfet_01v8 ad=0.0878 pd=0.92 as=0.169 ps=1.82 w=0.65 l=0.15
X299 VDPWR sky130_hd_xor_block_3.sky130_hd_xor2_1_0.A a_19527_33932# VDPWR sky130_fd_pr__pfet_01v8 ad=0.135 pd=1.27 as=0.135 ps=1.27 w=1 l=0.15
X300 VDPWR sky130_hd_xor_block_1.XORB sky130_hd_ro47_nand_0.sky130_hd_nand2_1_0.Y VDPWR sky130_fd_pr__pfet_01v8 ad=0.26 pd=2.52 as=0.135 ps=1.27 w=1 l=0.15
X301 sky130_hd_ro47_nand_0.sky130_hd_inv_1_20.Y sky130_hd_ro47_nand_0.sky130_hd_inv_1_21.Y uo_out[7] uo_out[7] sky130_fd_pr__nfet_01v8 ad=0.0878 pd=0.92 as=0.169 ps=1.82 w=0.65 l=0.15
X302 VDPWR sky130_hd_xor_block_2.XORB sky130_hd_ro41_nand_0.sky130_hd_nand2_1_0.Y VDPWR sky130_fd_pr__pfet_01v8 ad=0.26 pd=2.52 as=0.135 ps=1.27 w=1 l=0.15
X303 a_27903_3755# a_28188_3741# a_28123_3889# uo_out[7] sky130_fd_pr__special_nfet_01v8 ad=0.0684 pd=0.74 as=0.066 ps=0.745 w=0.36 l=0.15
X304 sky130_hd_ro41_nand_0.sky130_hd_nand2_1_0.Y sky130_hd_xor_block_2.XORB a_6379_29870# uo_out[7] sky130_fd_pr__nfet_01v8 ad=0.169 pd=1.82 as=0.0878 ps=0.92 w=0.65 l=0.15
X305 sky130_hd_ro37_nand_0.sky130_hd_inv_1_25.Y sky130_hd_ro37_nand_0.sky130_hd_inv_1_25.A uo_out[7] uo_out[7] sky130_fd_pr__nfet_01v8 ad=0.0878 pd=0.92 as=0.169 ps=1.82 w=0.65 l=0.15
X306 sky130_hd_ro47_nand_0.sky130_hd_inv_1_45.Y sky130_hd_ro47_nand_0.sky130_hd_nand2_1_0.Y VDPWR VDPWR sky130_fd_pr__pfet_01v8 ad=0.135 pd=1.27 as=0.26 ps=2.52 w=1 l=0.15
X307 uo_out[7] sky130_hd_ro32_nand_0.sky130_hd_inv_1_31.Y sky130_hd_ro32_nand_0.sky130_hd_inv_1_30.Y uo_out[7] sky130_fd_pr__nfet_01v8 ad=0.169 pd=1.82 as=0.0878 ps=0.92 w=0.65 l=0.15
X308 sky130_hd_ro32_nand_0.sky130_hd_inv_1_18.Y sky130_hd_ro32_nand_0.sky130_hd_inv_1_19.Y VDPWR VDPWR sky130_fd_pr__pfet_01v8 ad=0.135 pd=1.27 as=0.26 ps=2.52 w=1 l=0.15
X309 sky130_hd_ro37_nand_0.sky130_hd_inv_1_24.Y sky130_hd_ro37_nand_0.sky130_hd_inv_1_25.Y VDPWR VDPWR sky130_fd_pr__pfet_01v8 ad=0.135 pd=1.27 as=0.26 ps=2.52 w=1 l=0.15
X310 sky130_hd_xor_block_0.XOROUT a_24868_30833# a_25118_30833# VDPWR sky130_fd_pr__pfet_01v8 ad=0.3 pd=2.6 as=0.26 ps=2.52 w=1 l=0.15
X311 sky130_hd_ro32_nand_0.sky130_hd_inv_1_8.Y sky130_hd_ro32_nand_0.sky130_hd_inv_1_9.Y uo_out[7] uo_out[7] sky130_fd_pr__nfet_01v8 ad=0.0878 pd=0.92 as=0.169 ps=1.82 w=0.65 l=0.15
X312 uo_out[7] sky130_hd_ro33_nand_0.sky130_hd_inv_1_26.Y sky130_hd_ro33_nand_0.sky130_hd_inv_1_25.Y uo_out[7] sky130_fd_pr__nfet_01v8 ad=0.169 pd=1.82 as=0.0878 ps=0.92 w=0.65 l=0.15
X313 sky130_hd_ro37_nand_0.sky130_hd_inv_1_13.Y sky130_hd_ro37_nand_0.sky130_hd_inv_1_14.Y uo_out[7] uo_out[7] sky130_fd_pr__nfet_01v8 ad=0.0878 pd=0.92 as=0.169 ps=1.82 w=0.65 l=0.15
X314 VDPWR sky130_hd_ro47_nand_0.sky130_hd_inv_1_31.Y sky130_hd_ro47_nand_0.sky130_hd_inv_1_30.Y VDPWR sky130_fd_pr__pfet_01v8 ad=0.26 pd=2.52 as=0.135 ps=1.27 w=1 l=0.15
X315 sky130_hd_ro33_nand_0.sky130_hd_inv_1_19.Y sky130_hd_ro33_nand_0.sky130_hd_inv_1_20.Y uo_out[7] uo_out[7] sky130_fd_pr__nfet_01v8 ad=0.0878 pd=0.92 as=0.169 ps=1.82 w=0.65 l=0.15
X316 VDPWR sky130_hd_ro47_nand_0.sky130_hd_inv_1_9.A sky130_hd_ro47_nand_0.sky130_hd_inv_1_10.A VDPWR sky130_fd_pr__pfet_01v8 ad=0.26 pd=2.52 as=0.135 ps=1.27 w=1 l=0.15
X317 uo_out[7] sky130_hd_ro47_nand_0.sky130_hd_inv_1_39.Y sky130_hd_ro47_nand_0.sky130_hd_inv_1_38.Y uo_out[7] sky130_fd_pr__nfet_01v8 ad=0.169 pd=1.82 as=0.0878 ps=0.92 w=0.65 l=0.15
X318 VDPWR sky130_hd_ro53_nand_0.sky130_hd_inv_1_10.Y sky130_hd_ro53_nand_0.sky130_hd_inv_1_9.Y VDPWR sky130_fd_pr__pfet_01v8 ad=0.26 pd=2.52 as=0.135 ps=1.27 w=1 l=0.15
X319 sky130_hd_ro32_nand_0.sky130_hd_inv_1_15.Y sky130_hd_ro32_nand_0.sky130_hd_inv_1_16.Y VDPWR VDPWR sky130_fd_pr__pfet_01v8 ad=0.135 pd=1.27 as=0.26 ps=2.52 w=1 l=0.15
X320 VDPWR sky130_hd_ro33_nand_0.sky130_hd_inv_1_21.Y sky130_hd_ro33_nand_0.sky130_hd_inv_1_20.Y VDPWR sky130_fd_pr__pfet_01v8 ad=0.26 pd=2.52 as=0.135 ps=1.27 w=1 l=0.15
X321 VDPWR sky130_hd_ro37_nand_0.sky130_hd_inv_1_9.Y sky130_hd_ro37_nand_0.sky130_hd_inv_1_8.Y VDPWR sky130_fd_pr__pfet_01v8 ad=0.26 pd=2.52 as=0.135 ps=1.27 w=1 l=0.15
X322 sky130_hd_ro41_nand_0.sky130_hd_inv_1_24.Y sky130_hd_ro41_nand_0.sky130_hd_inv_1_25.Y VDPWR VDPWR sky130_fd_pr__pfet_01v8 ad=0.135 pd=1.27 as=0.26 ps=2.52 w=1 l=0.15
X323 sky130_hd_xor_block_1.sky130_hd_inv_1_1.Y sky130_hd_xor_block_1.XORB VDPWR VDPWR sky130_fd_pr__pfet_01v8 ad=0.135 pd=1.27 as=0.26 ps=2.52 w=1 l=0.15
X324 sky130_hd_ro41_nand_0.sky130_hd_inv_1_24.Y sky130_hd_ro41_nand_0.sky130_hd_inv_1_25.Y uo_out[7] uo_out[7] sky130_fd_pr__nfet_01v8 ad=0.0878 pd=0.92 as=0.169 ps=1.82 w=0.65 l=0.15
X325 sky130_hd_ro53_nand_0.sky130_hd_inv_1_3.Y sky130_hd_ro53_nand_0.sky130_hd_inv_1_4.Y VDPWR VDPWR sky130_fd_pr__pfet_01v8 ad=0.135 pd=1.27 as=0.26 ps=2.52 w=1 l=0.15
X326 sky130_hd_xor_block_0.sky130_hd_inv_1_3.A sky130_hd_xor_block_1.XOROUT uo_out[7] uo_out[7] sky130_fd_pr__nfet_01v8 ad=0.0878 pd=0.92 as=0.169 ps=1.82 w=0.65 l=0.15
X327 sky130_hd_ro41_nand_0.sky130_hd_inv_1_15.Y sky130_hd_ro41_nand_0.sky130_hd_inv_1_16.Y VDPWR VDPWR sky130_fd_pr__pfet_01v8 ad=0.135 pd=1.27 as=0.26 ps=2.52 w=1 l=0.15
X328 sky130_hd_ro41_nand_0.sky130_hd_inv_1_15.Y sky130_hd_ro41_nand_0.sky130_hd_inv_1_16.Y uo_out[7] uo_out[7] sky130_fd_pr__nfet_01v8 ad=0.0878 pd=0.92 as=0.169 ps=1.82 w=0.65 l=0.15
X329 VDPWR sky130_hd_ro47_nand_0.sky130_hd_inv_1_44.Y sky130_hd_ro47_nand_0.sky130_hd_inv_1_43.Y VDPWR sky130_fd_pr__pfet_01v8 ad=0.26 pd=2.52 as=0.135 ps=1.27 w=1 l=0.15
X330 VDPWR sky130_hd_ro33_nand_0.sky130_hd_inv_1_25.Y sky130_hd_ro33_nand_0.sky130_hd_inv_1_24.Y VDPWR sky130_fd_pr__pfet_01v8 ad=0.26 pd=2.52 as=0.135 ps=1.27 w=1 l=0.15
X331 VDPWR sky130_hd_ro32_nand_0.sky130_hd_inv_1_10.Y sky130_hd_ro32_nand_0.sky130_hd_inv_1_9.Y VDPWR sky130_fd_pr__pfet_01v8 ad=0.26 pd=2.52 as=0.135 ps=1.27 w=1 l=0.15
X332 sky130_hd_ro47_nand_0.sky130_hd_inv_1_7.A sky130_hd_ro47_nand_0.sky130_hd_inv_1_18.Y uo_out[7] uo_out[7] sky130_fd_pr__nfet_01v8 ad=0.0878 pd=0.92 as=0.169 ps=1.82 w=0.65 l=0.15
X333 sky130_hd_ro32_nand_0.sky130_hd_inv_1_12.Y sky130_hd_ro32_nand_0.sky130_hd_inv_1_13.Y uo_out[7] uo_out[7] sky130_fd_pr__nfet_01v8 ad=0.0878 pd=0.92 as=0.169 ps=1.82 w=0.65 l=0.15
X334 uo_out[7] sky130_hd_ro37_nand_0.sky130_hd_inv_1_31.Y sky130_hd_ro37_nand_0.sky130_hd_inv_1_30.Y uo_out[7] sky130_fd_pr__nfet_01v8 ad=0.169 pd=1.82 as=0.0878 ps=0.92 w=0.65 l=0.15
X335 VDPWR sky130_hd_ro53_nand_0.sky130_hd_inv_1_29.Y sky130_hd_ro53_nand_0.sky130_hd_inv_1_28.Y VDPWR sky130_fd_pr__pfet_01v8 ad=0.26 pd=2.52 as=0.135 ps=1.27 w=1 l=0.15
X336 uo_out[7] sky130_hd_ro53_nand_0.sky130_hd_inv_1_39.Y sky130_hd_ro53_nand_0.sky130_hd_inv_1_38.Y uo_out[7] sky130_fd_pr__nfet_01v8 ad=0.169 pd=1.82 as=0.0878 ps=0.92 w=0.65 l=0.15
X337 sky130_hd_ro37_nand_0.sky130_hd_inv_1_22.Y sky130_hd_ro37_nand_0.sky130_hd_inv_1_23.Y uo_out[7] uo_out[7] sky130_fd_pr__nfet_01v8 ad=0.0878 pd=0.92 as=0.169 ps=1.82 w=0.65 l=0.15
X338 sky130_hd_ro53_nand_0.sky130_hd_inv_1_11.Y sky130_hd_ro53_nand_0.sky130_hd_inv_1_22.Y uo_out[7] uo_out[7] sky130_fd_pr__nfet_01v8 ad=0.0878 pd=0.92 as=0.169 ps=1.82 w=0.65 l=0.15
X339 sky130_hd_ro47_nand_0.sky130_hd_inv_1_22.Y sky130_hd_ro47_nand_0.sky130_hd_inv_1_23.Y uo_out[7] uo_out[7] sky130_fd_pr__nfet_01v8 ad=0.0878 pd=0.92 as=0.169 ps=1.82 w=0.65 l=0.15
X340 sky130_hd_ro32_nand_0.sky130_hd_inv_1_9.Y sky130_hd_ro32_nand_0.sky130_hd_inv_1_10.Y uo_out[7] uo_out[7] sky130_fd_pr__nfet_01v8 ad=0.0878 pd=0.92 as=0.169 ps=1.82 w=0.65 l=0.15
X341 uo_out[7] sky130_hd_ro33_nand_0.sky130_hd_inv_1_23.Y sky130_hd_ro33_nand_0.sky130_hd_inv_1_22.Y uo_out[7] sky130_fd_pr__nfet_01v8 ad=0.169 pd=1.82 as=0.0878 ps=0.92 w=0.65 l=0.15
X342 VDPWR sky130_hd_ro41_nand_0.sky130_hd_inv_1_33.Y sky130_hd_ro41_nand_0.sky130_hd_inv_1_32.Y VDPWR sky130_fd_pr__pfet_01v8 ad=0.26 pd=2.52 as=0.135 ps=1.27 w=1 l=0.15
X343 sky130_hd_ro47_nand_0.sky130_hd_inv_1_41.Y sky130_hd_ro47_nand_0.sky130_hd_inv_1_42.Y uo_out[7] uo_out[7] sky130_fd_pr__nfet_01v8 ad=0.0878 pd=0.92 as=0.169 ps=1.82 w=0.65 l=0.15
X344 VDPWR sky130_hd_xor_block_0.sky130_hd_inv_1_3.A sky130_hd_xor_block_0.sky130_hd_xor2_1_0.B VDPWR sky130_fd_pr__pfet_01v8 ad=0.26 pd=2.52 as=0.135 ps=1.27 w=1 l=0.15
X345 uo_out[7] sky130_hd_ro41_nand_0.sky130_hd_inv_1_33.Y sky130_hd_ro41_nand_0.sky130_hd_inv_1_32.Y uo_out[7] sky130_fd_pr__nfet_01v8 ad=0.169 pd=1.82 as=0.0878 ps=0.92 w=0.65 l=0.15
X346 sky130_hd_ro32_nand_0.sky130_hd_inv_1_16.Y sky130_hd_ro32_nand_0.sky130_hd_inv_1_17.Y VDPWR VDPWR sky130_fd_pr__pfet_01v8 ad=0.135 pd=1.27 as=0.26 ps=2.52 w=1 l=0.15
X347 sky130_hd_ro33_nand_0.sky130_hd_inv_1_16.Y sky130_hd_ro33_nand_0.sky130_hd_inv_1_17.Y uo_out[7] uo_out[7] sky130_fd_pr__nfet_01v8 ad=0.0878 pd=0.92 as=0.169 ps=1.82 w=0.65 l=0.15
X348 a_24868_30833# sky130_hd_xor_block_0.sky130_hd_xor2_1_0.B uo_out[7] uo_out[7] sky130_fd_pr__nfet_01v8 ad=0.0878 pd=0.92 as=0.169 ps=1.82 w=0.65 l=0.15
X349 uo_out[7] a_24868_30833# sky130_hd_xor_block_0.XOROUT uo_out[7] sky130_fd_pr__nfet_01v8 ad=0.208 pd=1.94 as=0.25 ps=1.42 w=0.65 l=0.15
X350 VDPWR sky130_hd_ro47_nand_0.sky130_hd_inv_1_12.A sky130_hd_ro47_nand_0.sky130_hd_inv_1_13.A VDPWR sky130_fd_pr__pfet_01v8 ad=0.26 pd=2.52 as=0.135 ps=1.27 w=1 l=0.15
X351 sky130_hd_xor_block_1.XORB sky130_hd_ro47_nand_0.sky130_hd_inv_1_1.Y VDPWR VDPWR sky130_fd_pr__pfet_01v8 ad=0.135 pd=1.27 as=0.26 ps=2.52 w=1 l=0.15
X352 VDPWR sky130_hd_ro53_nand_0.sky130_hd_inv_1_7.Y sky130_hd_ro53_nand_0.sky130_hd_inv_1_6.Y VDPWR sky130_fd_pr__pfet_01v8 ad=0.26 pd=2.52 as=0.135 ps=1.27 w=1 l=0.15
X353 VDPWR sky130_hd_ro33_nand_0.sky130_hd_inv_1_18.Y sky130_hd_ro33_nand_0.sky130_hd_inv_1_17.Y VDPWR sky130_fd_pr__pfet_01v8 ad=0.26 pd=2.52 as=0.135 ps=1.27 w=1 l=0.15
X354 uo_out[7] sky130_hd_ro37_nand_0.sky130_hd_nand2_1_0.Y sky130_hd_ro37_nand_0.sky130_hd_inv_1_35.Y uo_out[7] sky130_fd_pr__nfet_01v8 ad=0.169 pd=1.82 as=0.0878 ps=0.92 w=0.65 l=0.15
X355 a_19527_33932# sky130_hd_xor_block_3.sky130_hd_xor2_1_0.B a_19445_33932# VDPWR sky130_fd_pr__pfet_01v8 ad=0.135 pd=1.27 as=0.26 ps=2.52 w=1 l=0.15
X356 VDPWR sky130_hd_ro37_nand_0.sky130_hd_inv_1_35.Y sky130_hd_ro37_nand_0.sky130_hd_inv_1_34.Y VDPWR sky130_fd_pr__pfet_01v8 ad=0.26 pd=2.52 as=0.135 ps=1.27 w=1 l=0.15
X357 uo_out[7] sky130_hd_ro32_nand_0.sky130_hd_inv_1_20.Y sky130_hd_ro32_nand_0.sky130_hd_inv_1_19.Y uo_out[7] sky130_fd_pr__nfet_01v8 ad=0.169 pd=1.82 as=0.0878 ps=0.92 w=0.65 l=0.15
X358 sky130_hd_ro37_nand_0.sky130_hd_inv_1_25.A sky130_hd_ro37_nand_0.sky130_hd_inv_1_26.Y VDPWR VDPWR sky130_fd_pr__pfet_01v8 ad=0.135 pd=1.27 as=0.26 ps=2.52 w=1 l=0.15
X359 sky130_hd_xor_block_3.XOROUT a_19445_33932# a_19695_33932# VDPWR sky130_fd_pr__pfet_01v8 ad=0.3 pd=2.6 as=0.26 ps=2.52 w=1 l=0.15
X360 sky130_hd_ro33_nand_0.sky130_hd_inv_1_28.Y sky130_hd_ro33_nand_0.sky130_hd_inv_1_29.Y VDPWR VDPWR sky130_fd_pr__pfet_01v8 ad=0.135 pd=1.27 as=0.26 ps=2.52 w=1 l=0.15
X361 uo_out[7] sky130_hd_ro33_nand_0.sky130_hd_inv_1_1.Y sky130_hd_xor_block_3.XORA uo_out[7] sky130_fd_pr__nfet_01v8 ad=0.169 pd=1.82 as=0.0878 ps=0.92 w=0.65 l=0.15
X362 sky130_hd_ro41_nand_0.sky130_hd_nand2_1_0.Y ui_in[5] VDPWR VDPWR sky130_fd_pr__pfet_01v8 ad=0.135 pd=1.27 as=0.26 ps=2.52 w=1 l=0.15
X363 uo_out[7] sky130_hd_ro53_nand_0.sky130_hd_inv_1_32.Y sky130_hd_ro53_nand_0.sky130_hd_inv_1_31.Y uo_out[7] sky130_fd_pr__nfet_01v8 ad=0.169 pd=1.82 as=0.0878 ps=0.92 w=0.65 l=0.15
X364 uo_out[7] sky130_hd_xor_block_2.XOROUT sky130_hd_xor_block_1.sky130_hd_inv_1_3.A uo_out[7] sky130_fd_pr__nfet_01v8 ad=0.169 pd=1.82 as=0.0878 ps=0.92 w=0.65 l=0.15
X365 a_6379_29870# ui_in[5] uo_out[7] uo_out[7] sky130_fd_pr__nfet_01v8 ad=0.0878 pd=0.92 as=0.169 ps=1.82 w=0.65 l=0.15
X366 a_27746_2979# sky130_hd_div_by_2_3.Qb VDPWR VDPWR sky130_fd_pr__pfet_01v8_hvt ad=0.0578 pd=0.695 as=0.109 ps=1.36 w=0.42 l=0.15
X367 sky130_hd_ro53_nand_0.sky130_hd_inv_1_4.Y sky130_hd_ro53_nand_0.sky130_hd_inv_1_5.Y uo_out[7] uo_out[7] sky130_fd_pr__nfet_01v8 ad=0.0878 pd=0.92 as=0.169 ps=1.82 w=0.65 l=0.15
X368 sky130_hd_ro33_nand_0.sky130_hd_inv_1_21.Y sky130_hd_ro33_nand_0.sky130_hd_inv_1_22.Y uo_out[7] uo_out[7] sky130_fd_pr__nfet_01v8 ad=0.0878 pd=0.92 as=0.169 ps=1.82 w=0.65 l=0.15
X369 uo_out[7] sky130_hd_ro47_nand_0.sky130_hd_inv_1_40.Y sky130_hd_ro47_nand_0.sky130_hd_inv_1_39.Y uo_out[7] sky130_fd_pr__nfet_01v8 ad=0.169 pd=1.82 as=0.0878 ps=0.92 w=0.65 l=0.15
X370 VDPWR sky130_hd_ro53_nand_0.sky130_hd_inv_1_33.Y sky130_hd_ro53_nand_0.sky130_hd_inv_1_32.Y VDPWR sky130_fd_pr__pfet_01v8 ad=0.26 pd=2.52 as=0.135 ps=1.27 w=1 l=0.15
X371 VDPWR sky130_hd_ro32_nand_0.sky130_hd_inv_1_24.Y sky130_hd_ro32_nand_0.sky130_hd_inv_1_23.Y VDPWR sky130_fd_pr__pfet_01v8 ad=0.26 pd=2.52 as=0.135 ps=1.27 w=1 l=0.15
X372 sky130_hd_xor_block_3.sky130_hd_inv_1_3.A sky130_hd_xor_block_3.XORA uo_out[7] uo_out[7] sky130_fd_pr__nfet_01v8 ad=0.0878 pd=0.92 as=0.169 ps=1.82 w=0.65 l=0.15
X373 sky130_hd_ro47_nand_0.sky130_hd_inv_1_19.Y sky130_hd_ro47_nand_0.sky130_hd_inv_1_20.Y VDPWR VDPWR sky130_fd_pr__pfet_01v8 ad=0.135 pd=1.27 as=0.26 ps=2.52 w=1 l=0.15
X374 sky130_hd_ro47_nand_0.sky130_hd_inv_1_35.Y sky130_hd_ro47_nand_0.sky130_hd_inv_1_35.A uo_out[7] uo_out[7] sky130_fd_pr__nfet_01v8 ad=0.0878 pd=0.92 as=0.169 ps=1.82 w=0.65 l=0.15
X375 uo_out[7] sky130_hd_ro53_nand_0.sky130_hd_inv_1_36.Y sky130_hd_ro53_nand_0.sky130_hd_inv_1_35.Y uo_out[7] sky130_fd_pr__nfet_01v8 ad=0.169 pd=1.82 as=0.0878 ps=0.92 w=0.65 l=0.15
X376 sky130_hd_ro53_nand_0.sky130_hd_inv_1_8.Y sky130_hd_ro53_nand_0.sky130_hd_inv_1_9.Y uo_out[7] uo_out[7] sky130_fd_pr__nfet_01v8 ad=0.0878 pd=0.92 as=0.169 ps=1.82 w=0.65 l=0.15
X377 sky130_hd_ro33_nand_0.sky130_hd_inv_1_25.Y sky130_hd_ro33_nand_0.sky130_hd_inv_1_26.Y uo_out[7] uo_out[7] sky130_fd_pr__nfet_01v8 ad=0.0878 pd=0.92 as=0.169 ps=1.82 w=0.65 l=0.15
X378 sky130_hd_ro32_nand_0.sky130_hd_inv_1_26.Y sky130_hd_ro32_nand_0.sky130_hd_inv_1_27.Y uo_out[7] uo_out[7] sky130_fd_pr__nfet_01v8 ad=0.0878 pd=0.92 as=0.169 ps=1.82 w=0.65 l=0.15
X379 VDPWR sky130_hd_ro33_nand_0.sky130_hd_inv_1_27.Y sky130_hd_ro33_nand_0.sky130_hd_inv_1_26.Y VDPWR sky130_fd_pr__pfet_01v8 ad=0.26 pd=2.52 as=0.135 ps=1.27 w=1 l=0.15
X380 sky130_hd_ro53_nand_0.sky130_hd_inv_1_9.Y sky130_hd_ro53_nand_0.sky130_hd_inv_1_10.Y VDPWR VDPWR sky130_fd_pr__pfet_01v8 ad=0.135 pd=1.27 as=0.26 ps=2.52 w=1 l=0.15
X381 a_28256_3345# a_27558_2979# a_27999_3091# uo_out[7] sky130_fd_pr__special_nfet_01v8 ad=0.0684 pd=0.74 as=0.0989 ps=0.995 w=0.36 l=0.15
X382 uo_out[7] sky130_hd_ro53_nand_0.sky130_hd_inv_1_49.Y sky130_hd_ro53_nand_0.sky130_hd_inv_1_48.Y uo_out[7] sky130_fd_pr__nfet_01v8 ad=0.169 pd=1.82 as=0.0878 ps=0.92 w=0.65 l=0.15
X383 uo_out[7] sky130_hd_xor_block_2.sky130_hd_inv_1_3.A sky130_hd_xor_block_2.sky130_hd_xor2_1_0.B uo_out[7] sky130_fd_pr__nfet_01v8 ad=0.169 pd=1.82 as=0.0878 ps=0.92 w=0.65 l=0.15
X384 sky130_hd_ro33_nand_0.sky130_hd_inv_1_13.Y sky130_hd_ro33_nand_0.sky130_hd_inv_1_14.Y uo_out[7] uo_out[7] sky130_fd_pr__nfet_01v8 ad=0.0878 pd=0.92 as=0.169 ps=1.82 w=0.65 l=0.15
X385 uo_out[7] sky130_hd_ro37_nand_0.sky130_hd_inv_1_33.Y sky130_hd_ro37_nand_0.sky130_hd_inv_1_32.Y uo_out[7] sky130_fd_pr__nfet_01v8 ad=0.169 pd=1.82 as=0.0878 ps=0.92 w=0.65 l=0.15
X386 uo_out[7] sky130_hd_ro53_nand_0.sky130_hd_inv_1_41.Y sky130_hd_ro53_nand_0.sky130_hd_inv_1_40.Y uo_out[7] sky130_fd_pr__nfet_01v8 ad=0.169 pd=1.82 as=0.0878 ps=0.92 w=0.65 l=0.15
X387 sky130_hd_ro47_nand_0.sky130_hd_inv_1_43.Y sky130_hd_ro47_nand_0.sky130_hd_inv_1_44.Y VDPWR VDPWR sky130_fd_pr__pfet_01v8 ad=0.135 pd=1.27 as=0.26 ps=2.52 w=1 l=0.15
X388 VDPWR sky130_hd_ro53_nand_0.sky130_hd_inv_1_50.Y sky130_hd_ro53_nand_0.sky130_hd_inv_1_49.Y VDPWR sky130_fd_pr__pfet_01v8 ad=0.26 pd=2.52 as=0.135 ps=1.27 w=1 l=0.15
X389 uo_out[7] sky130_hd_ro32_nand_0.sky130_hd_inv_1_21.Y sky130_hd_ro32_nand_0.sky130_hd_inv_1_20.Y uo_out[7] sky130_fd_pr__nfet_01v8 ad=0.169 pd=1.82 as=0.0878 ps=0.92 w=0.65 l=0.15
X390 sky130_hd_ro53_nand_0.sky130_hd_inv_1_21.A sky130_hd_ro53_nand_0.sky130_hd_inv_1_20.A VDPWR VDPWR sky130_fd_pr__pfet_01v8 ad=0.135 pd=1.27 as=0.26 ps=2.52 w=1 l=0.15
X391 sky130_hd_ro47_nand_0.sky130_hd_inv_1_32.Y sky130_hd_ro47_nand_0.sky130_hd_inv_1_33.Y VDPWR VDPWR sky130_fd_pr__pfet_01v8 ad=0.135 pd=1.27 as=0.26 ps=2.52 w=1 l=0.15
X392 sky130_hd_ro37_nand_0.sky130_hd_inv_1_10.Y sky130_hd_ro37_nand_0.sky130_hd_inv_1_11.Y VDPWR VDPWR sky130_fd_pr__pfet_01v8 ad=0.135 pd=1.27 as=0.26 ps=2.52 w=1 l=0.15
X393 sky130_hd_ro37_nand_0.sky130_hd_inv_1_11.Y sky130_hd_ro37_nand_0.sky130_hd_inv_1_12.Y uo_out[7] uo_out[7] sky130_fd_pr__nfet_01v8 ad=0.0878 pd=0.92 as=0.169 ps=1.82 w=0.65 l=0.15
X394 sky130_hd_ro53_nand_0.sky130_hd_inv_1_28.Y sky130_hd_ro53_nand_0.sky130_hd_inv_1_29.Y VDPWR VDPWR sky130_fd_pr__pfet_01v8 ad=0.135 pd=1.27 as=0.26 ps=2.52 w=1 l=0.15
X395 a_28256_2257# a_27558_1891# a_27999_2003# uo_out[7] sky130_fd_pr__special_nfet_01v8 ad=0.0684 pd=0.74 as=0.0989 ps=0.995 w=0.36 l=0.15
X396 a_19286_4740# ena uo_out[7] uo_out[7] sky130_fd_pr__nfet_01v8 ad=0.0878 pd=0.92 as=0.169 ps=1.82 w=0.65 l=0.15
X397 sky130_hd_ro33_nand_0.sky130_hd_inv_1_18.Y sky130_hd_ro33_nand_0.sky130_hd_inv_1_19.Y uo_out[7] uo_out[7] sky130_fd_pr__nfet_01v8 ad=0.0878 pd=0.92 as=0.169 ps=1.82 w=0.65 l=0.15
X398 uo_out[7] sky130_hd_ro47_nand_0.sky130_hd_inv_1_37.Y sky130_hd_ro47_nand_0.sky130_hd_inv_1_36.Y uo_out[7] sky130_fd_pr__nfet_01v8 ad=0.169 pd=1.82 as=0.0878 ps=0.92 w=0.65 l=0.15
X399 sky130_hd_ro53_nand_0.sky130_hd_inv_1_2.Y sky130_hd_ro53_nand_0.sky130_hd_inv_1_3.Y VDPWR VDPWR sky130_fd_pr__pfet_01v8 ad=0.135 pd=1.27 as=0.26 ps=2.52 w=1 l=0.15
X400 sky130_hd_ro33_nand_0.sky130_hd_inv_1_22.Y sky130_hd_ro33_nand_0.sky130_hd_inv_1_23.Y uo_out[7] uo_out[7] sky130_fd_pr__nfet_01v8 ad=0.0878 pd=0.92 as=0.169 ps=1.82 w=0.65 l=0.15
X401 sky130_hd_xor_block_1.sky130_hd_xor2_1_0.A sky130_hd_xor_block_1.sky130_hd_inv_1_1.Y uo_out[7] uo_out[7] sky130_fd_pr__nfet_01v8 ad=0.0878 pd=0.92 as=0.169 ps=1.82 w=0.65 l=0.15
X402 VDPWR sky130_hd_ro41_nand_0.sky130_hd_inv_1_4.A sky130_hd_ro41_nand_0.sky130_hd_inv_1_5.A VDPWR sky130_fd_pr__pfet_01v8 ad=0.26 pd=2.52 as=0.135 ps=1.27 w=1 l=0.15
X403 uo_out[7] sky130_hd_ro41_nand_0.sky130_hd_inv_1_4.A sky130_hd_ro41_nand_0.sky130_hd_inv_1_5.A uo_out[7] sky130_fd_pr__nfet_01v8 ad=0.169 pd=1.82 as=0.0878 ps=0.92 w=0.65 l=0.15
X404 sky130_hd_ro53_nand_0.sky130_hd_inv_1_5.Y sky130_hd_ro53_nand_0.sky130_hd_inv_1_6.Y uo_out[7] uo_out[7] sky130_fd_pr__nfet_01v8 ad=0.0878 pd=0.92 as=0.169 ps=1.82 w=0.65 l=0.15
X405 sky130_hd_xor_block_0.sky130_hd_xor2_1_0.B sky130_hd_xor_block_0.sky130_hd_inv_1_3.A VDPWR VDPWR sky130_fd_pr__pfet_01v8 ad=0.135 pd=1.27 as=0.26 ps=2.52 w=1 l=0.15
X406 uo_out[7] sky130_hd_ro47_nand_0.sky130_hd_inv_1_26.Y sky130_hd_ro47_nand_0.sky130_hd_inv_1_25.Y uo_out[7] sky130_fd_pr__nfet_01v8 ad=0.169 pd=1.82 as=0.0878 ps=0.92 w=0.65 l=0.15
X407 sky130_hd_ro32_nand_0.sky130_hd_inv_1_2.Y sky130_hd_ro32_nand_0.sky130_hd_inv_1_3.Y VDPWR VDPWR sky130_fd_pr__pfet_01v8 ad=0.135 pd=1.27 as=0.26 ps=2.52 w=1 l=0.15
X408 sky130_hd_ro53_nand_0.sky130_hd_inv_1_51.Y sky130_hd_ro53_nand_0.sky130_hd_nand2_1_0.Y uo_out[7] uo_out[7] sky130_fd_pr__nfet_01v8 ad=0.0878 pd=0.92 as=0.169 ps=1.82 w=0.65 l=0.15
X409 sky130_hd_ro53_nand_0.sky130_hd_inv_1_6.Y sky130_hd_ro53_nand_0.sky130_hd_inv_1_7.Y VDPWR VDPWR sky130_fd_pr__pfet_01v8 ad=0.135 pd=1.27 as=0.26 ps=2.52 w=1 l=0.15
X410 sky130_hd_ro33_nand_0.sky130_hd_inv_1_17.Y sky130_hd_ro33_nand_0.sky130_hd_inv_1_18.Y VDPWR VDPWR sky130_fd_pr__pfet_01v8 ad=0.135 pd=1.27 as=0.26 ps=2.52 w=1 l=0.15
X411 sky130_hd_ro37_nand_0.sky130_hd_inv_1_15.Y sky130_hd_ro37_nand_0.sky130_hd_inv_1_16.Y VDPWR VDPWR sky130_fd_pr__pfet_01v8 ad=0.135 pd=1.27 as=0.26 ps=2.52 w=1 l=0.15
X412 uo_out[7] a_28188_2653# a_28195_2557# uo_out[7] sky130_fd_pr__nfet_01v8 ad=0.0567 pd=0.69 as=0.109 ps=1.36 w=0.42 l=0.15
X413 VDPWR sky130_hd_ro47_nand_0.sky130_hd_inv_1_4.Y sky130_hd_ro47_nand_0.sky130_hd_inv_1_3.Y VDPWR sky130_fd_pr__pfet_01v8 ad=0.26 pd=2.52 as=0.135 ps=1.27 w=1 l=0.15
X414 uo_out[7] sky130_hd_ro37_nand_0.sky130_hd_inv_1_30.Y sky130_hd_ro37_nand_0.sky130_hd_inv_1_29.Y uo_out[7] sky130_fd_pr__nfet_01v8 ad=0.169 pd=1.82 as=0.0878 ps=0.92 w=0.65 l=0.15
X415 sky130_hd_ro47_nand_0.sky130_hd_inv_1_35.A sky130_hd_ro47_nand_0.sky130_hd_inv_1_36.Y uo_out[7] uo_out[7] sky130_fd_pr__nfet_01v8 ad=0.0878 pd=0.92 as=0.169 ps=1.82 w=0.65 l=0.15
X416 sky130_hd_ro47_nand_0.sky130_hd_inv_1_40.Y sky130_hd_ro47_nand_0.sky130_hd_inv_1_41.Y VDPWR VDPWR sky130_fd_pr__pfet_01v8 ad=0.135 pd=1.27 as=0.26 ps=2.52 w=1 l=0.15
X417 sky130_hd_ro37_nand_0.sky130_hd_inv_1_19.Y sky130_hd_ro37_nand_0.sky130_hd_inv_1_20.Y VDPWR VDPWR sky130_fd_pr__pfet_01v8 ad=0.135 pd=1.27 as=0.26 ps=2.52 w=1 l=0.15
X418 sky130_hd_ro53_nand_0.sky130_hd_inv_1_15.A sky130_hd_ro53_nand_0.sky130_hd_inv_1_14.A VDPWR VDPWR sky130_fd_pr__pfet_01v8 ad=0.135 pd=1.27 as=0.26 ps=2.52 w=1 l=0.15
X419 sky130_hd_ro53_nand_0.sky130_hd_inv_1_31.Y sky130_hd_ro53_nand_0.sky130_hd_inv_1_32.Y uo_out[7] uo_out[7] sky130_fd_pr__nfet_01v8 ad=0.0878 pd=0.92 as=0.169 ps=1.82 w=0.65 l=0.15
X420 VDPWR sky130_hd_ro33_nand_0.sky130_hd_inv_1_12.Y sky130_hd_ro33_nand_0.sky130_hd_inv_1_11.Y VDPWR sky130_fd_pr__pfet_01v8 ad=0.26 pd=2.52 as=0.135 ps=1.27 w=1 l=0.15
X421 a_27831_2257# a_27558_1891# a_27746_1891# VDPWR sky130_fd_pr__pfet_01v8_hvt ad=0.0683 pd=0.745 as=0.0578 ps=0.695 w=0.42 l=0.15
X422 VDPWR a_28424_2159# a_28855_2213# VDPWR sky130_fd_pr__pfet_01v8_hvt ad=0.154 pd=1.34 as=0.166 ps=1.8 w=0.64 l=0.15
X423 sky130_hd_ro53_nand_0.sky130_hd_inv_1_24.Y sky130_hd_ro53_nand_0.sky130_hd_inv_1_25.Y uo_out[7] uo_out[7] sky130_fd_pr__nfet_01v8 ad=0.0878 pd=0.92 as=0.169 ps=1.82 w=0.65 l=0.15
X424 uo_out[7] a_28395_2712# a_28324_2813# uo_out[7] sky130_fd_pr__nfet_01v8 ad=0.121 pd=1.09 as=0.0989 ps=0.995 w=0.64 l=0.15
X425 VDPWR a_27631_3850# sky130_hd_div_by_2_4.Q VDPWR sky130_fd_pr__pfet_01v8_hvt ad=0.135 pd=1.27 as=0.26 ps=2.52 w=1 l=0.15
X426 a_22194_35563# a_22065_35837# a_21774_35537# uo_out[7] sky130_fd_pr__special_nfet_01v8 ad=0.0989 pd=0.995 as=0.0684 ps=0.74 w=0.36 l=0.15
X427 sky130_hd_ro37_nand_0.sky130_hd_inv_1_8.Y sky130_hd_ro37_nand_0.sky130_hd_inv_1_9.Y uo_out[7] uo_out[7] sky130_fd_pr__nfet_01v8 ad=0.0878 pd=0.92 as=0.169 ps=1.82 w=0.65 l=0.15
X428 VDPWR sky130_hd_ro47_nand_0.sky130_hd_inv_1_14.A sky130_hd_ro47_nand_0.sky130_hd_inv_1_15.A VDPWR sky130_fd_pr__pfet_01v8 ad=0.26 pd=2.52 as=0.135 ps=1.27 w=1 l=0.15
X429 sky130_hd_ro53_nand_0.sky130_hd_inv_1_25.Y sky130_hd_ro53_nand_0.sky130_hd_inv_1_26.Y VDPWR VDPWR sky130_fd_pr__pfet_01v8 ad=0.135 pd=1.27 as=0.26 ps=2.52 w=1 l=0.15
X430 uo_out[7] a_28256_3345# a_28424_3247# uo_out[7] sky130_fd_pr__nfet_01v8 ad=0.0878 pd=0.92 as=0.169 ps=1.82 w=0.65 l=0.15
X431 VDPWR sky130_hd_ro33_nand_0.sky130_hd_inv_1_16.Y sky130_hd_ro33_nand_0.sky130_hd_inv_1_15.Y VDPWR sky130_fd_pr__pfet_01v8 ad=0.26 pd=2.52 as=0.135 ps=1.27 w=1 l=0.15
X432 VDPWR sky130_hd_ro41_nand_0.sky130_hd_inv_1_29.A sky130_hd_ro41_nand_0.sky130_hd_inv_1_29.Y VDPWR sky130_fd_pr__pfet_01v8 ad=0.26 pd=2.52 as=0.135 ps=1.27 w=1 l=0.15
X433 VDPWR sky130_hd_ro53_nand_0.sky130_hd_nand2_1_0.Y sky130_hd_ro53_nand_0.sky130_hd_inv_1_51.Y VDPWR sky130_fd_pr__pfet_01v8 ad=0.26 pd=2.52 as=0.135 ps=1.27 w=1 l=0.15
X434 uo_out[7] sky130_hd_ro41_nand_0.sky130_hd_inv_1_29.A sky130_hd_ro41_nand_0.sky130_hd_inv_1_29.Y uo_out[7] sky130_fd_pr__nfet_01v8 ad=0.169 pd=1.82 as=0.0878 ps=0.92 w=0.65 l=0.15
X435 uo_out[7] a_21678_35715# sky130_hd_inv_1_0.A uo_out[7] sky130_fd_pr__nfet_01v8 ad=0.0878 pd=0.92 as=0.169 ps=1.82 w=0.65 l=0.15
X436 sky130_hd_ro33_nand_0.sky130_hd_inv_1_10.Y sky130_hd_ro33_nand_0.sky130_hd_inv_1_11.Y VDPWR VDPWR sky130_fd_pr__pfet_01v8 ad=0.135 pd=1.27 as=0.26 ps=2.52 w=1 l=0.15
X437 sky130_hd_ro53_nand_0.sky130_hd_inv_1_48.Y sky130_hd_ro53_nand_0.sky130_hd_inv_1_49.Y uo_out[7] uo_out[7] sky130_fd_pr__nfet_01v8 ad=0.0878 pd=0.92 as=0.169 ps=1.82 w=0.65 l=0.15
X438 sky130_hd_inv_4_0.A sky130_hd_inv_1_0.A VDPWR VDPWR sky130_fd_pr__pfet_01v8 ad=0.135 pd=1.27 as=0.26 ps=2.52 w=1 l=0.15
X439 sky130_hd_ro33_nand_0.sky130_hd_inv_1_2.Y sky130_hd_ro33_nand_0.sky130_hd_inv_1_3.Y uo_out[7] uo_out[7] sky130_fd_pr__nfet_01v8 ad=0.0878 pd=0.92 as=0.169 ps=1.82 w=0.65 l=0.15
X440 sky130_hd_ro41_nand_0.sky130_hd_inv_1_39.Y sky130_hd_ro41_nand_0.sky130_hd_nand2_1_0.Y VDPWR VDPWR sky130_fd_pr__pfet_01v8 ad=0.135 pd=1.27 as=0.26 ps=2.52 w=1 l=0.15
X441 sky130_hd_ro41_nand_0.sky130_hd_inv_1_39.Y sky130_hd_ro41_nand_0.sky130_hd_nand2_1_0.Y uo_out[7] uo_out[7] sky130_fd_pr__nfet_01v8 ad=0.0878 pd=0.92 as=0.169 ps=1.82 w=0.65 l=0.15
X442 VDPWR a_27999_2003# a_27926_2257# VDPWR sky130_fd_pr__pfet_01v8_hvt ad=0.179 pd=1.26 as=0.0767 ps=0.785 w=0.42 l=0.15
X443 uo_out[7] sky130_hd_xor_block_1.sky130_hd_inv_1_3.A sky130_hd_xor_block_1.sky130_hd_xor2_1_0.B uo_out[7] sky130_fd_pr__nfet_01v8 ad=0.169 pd=1.82 as=0.0878 ps=0.92 w=0.65 l=0.15
X444 uo_out[7] a_27999_3091# a_27957_2979# uo_out[7] sky130_fd_pr__nfet_01v8 ad=0.121 pd=1.09 as=0.0696 ps=0.765 w=0.42 l=0.15
X445 sky130_hd_ro37_nand_0.sky130_hd_inv_1_32.Y sky130_hd_ro37_nand_0.sky130_hd_inv_1_33.Y uo_out[7] uo_out[7] sky130_fd_pr__nfet_01v8 ad=0.0878 pd=0.92 as=0.169 ps=1.82 w=0.65 l=0.15
X446 VDPWR sky130_hd_ro53_nand_0.sky130_hd_inv_1_31.Y sky130_hd_ro53_nand_0.sky130_hd_inv_1_30.Y VDPWR sky130_fd_pr__pfet_01v8 ad=0.26 pd=2.52 as=0.135 ps=1.27 w=1 l=0.15
X447 uo_out[7] a_28256_2257# a_28424_2159# uo_out[7] sky130_fd_pr__nfet_01v8 ad=0.0878 pd=0.92 as=0.169 ps=1.82 w=0.65 l=0.15
X448 uo_out[7] sky130_hd_ro32_nand_0.sky130_hd_inv_1_7.Y sky130_hd_ro32_nand_0.sky130_hd_inv_1_6.Y uo_out[7] sky130_fd_pr__nfet_01v8 ad=0.169 pd=1.82 as=0.0878 ps=0.92 w=0.65 l=0.15
X449 uo_out[0] sky130_hd_inv_4_0.A VDPWR VDPWR sky130_fd_pr__pfet_01v8_hvt ad=0.135 pd=1.27 as=0.26 ps=2.52 w=1 l=0.15
X450 uo_out[7] sky130_hd_xor_block_0.sky130_hd_xor2_1_0.A a_24868_30833# uo_out[7] sky130_fd_pr__nfet_01v8 ad=0.0878 pd=0.92 as=0.0878 ps=0.92 w=0.65 l=0.15
X451 sky130_hd_ro32_nand_0.sky130_hd_inv_1_23.Y sky130_hd_ro32_nand_0.sky130_hd_inv_1_24.Y VDPWR VDPWR sky130_fd_pr__pfet_01v8 ad=0.135 pd=1.27 as=0.26 ps=2.52 w=1 l=0.15
X452 VDPWR sky130_hd_xor_block_0.XOROUT a_24677_35563# VDPWR sky130_fd_pr__pfet_01v8_hvt ad=0.109 pd=1.36 as=0.0578 ps=0.695 w=0.42 l=0.15
X453 sky130_hd_ro47_nand_0.sky130_hd_inv_1_37.Y sky130_hd_ro47_nand_0.sky130_hd_inv_1_38.Y VDPWR VDPWR sky130_fd_pr__pfet_01v8 ad=0.135 pd=1.27 as=0.26 ps=2.52 w=1 l=0.15
X454 sky130_hd_ro47_nand_0.sky130_hd_inv_1_33.Y sky130_hd_ro47_nand_0.sky130_hd_inv_1_34.Y uo_out[7] uo_out[7] sky130_fd_pr__nfet_01v8 ad=0.0878 pd=0.92 as=0.169 ps=1.82 w=0.65 l=0.15
X455 uo_out[7] sky130_hd_ro53_nand_0.sky130_hd_inv_1_34.Y sky130_hd_ro53_nand_0.sky130_hd_inv_1_33.Y uo_out[7] sky130_fd_pr__nfet_01v8 ad=0.169 pd=1.82 as=0.0878 ps=0.92 w=0.65 l=0.15
X456 uo_out[7] sky130_hd_xor_block_2.sky130_hd_inv_1_1.Y sky130_hd_xor_block_2.sky130_hd_xor2_1_0.A uo_out[7] sky130_fd_pr__nfet_01v8 ad=0.169 pd=1.82 as=0.0878 ps=0.92 w=0.65 l=0.15
X457 sky130_hd_ro37_nand_0.sky130_hd_inv_1_17.Y sky130_hd_ro37_nand_0.sky130_hd_inv_1_18.Y uo_out[7] uo_out[7] sky130_fd_pr__nfet_01v8 ad=0.0878 pd=0.92 as=0.169 ps=1.82 w=0.65 l=0.15
X458 sky130_hd_ro33_nand_0.sky130_hd_inv_1_7.Y sky130_hd_ro33_nand_0.sky130_hd_inv_1_8.Y uo_out[7] uo_out[7] sky130_fd_pr__nfet_01v8 ad=0.0878 pd=0.92 as=0.169 ps=1.82 w=0.65 l=0.15
X459 sky130_hd_ro47_nand_0.sky130_hd_nand2_1_0.Y ui_in[6] VDPWR VDPWR sky130_fd_pr__pfet_01v8 ad=0.135 pd=1.27 as=0.26 ps=2.52 w=1 l=0.15
X460 a_27926_2257# a_27392_1891# a_27831_2257# VDPWR sky130_fd_pr__pfet_01v8_hvt ad=0.0767 pd=0.785 as=0.0683 ps=0.745 w=0.42 l=0.15
X461 sky130_hd_ro32_nand_0.sky130_hd_inv_1_13.Y sky130_hd_ro32_nand_0.sky130_hd_inv_1_14.Y uo_out[7] uo_out[7] sky130_fd_pr__nfet_01v8 ad=0.0878 pd=0.92 as=0.169 ps=1.82 w=0.65 l=0.15
X462 VDPWR sky130_hd_xor_block_3.sky130_hd_inv_1_1.Y sky130_hd_xor_block_3.sky130_hd_xor2_1_0.A VDPWR sky130_fd_pr__pfet_01v8 ad=0.26 pd=2.52 as=0.135 ps=1.27 w=1 l=0.15
X463 VDPWR sky130_hd_xor_block_0.XORB sky130_hd_xor_block_0.sky130_hd_inv_1_1.Y VDPWR sky130_fd_pr__pfet_01v8 ad=0.26 pd=2.52 as=0.135 ps=1.27 w=1 l=0.15
X464 uo_out[7] sky130_hd_ro32_nand_0.sky130_hd_inv_1_4.Y sky130_hd_ro32_nand_0.sky130_hd_inv_1_3.Y uo_out[7] sky130_fd_pr__nfet_01v8 ad=0.169 pd=1.82 as=0.0878 ps=0.92 w=0.65 l=0.15
X465 sky130_hd_ro41_nand_0.sky130_hd_inv_1_31.Y sky130_hd_ro41_nand_0.sky130_hd_inv_1_32.Y VDPWR VDPWR sky130_fd_pr__pfet_01v8 ad=0.135 pd=1.27 as=0.26 ps=2.52 w=1 l=0.15
X466 sky130_hd_ro47_nand_0.sky130_hd_inv_1_36.Y sky130_hd_ro47_nand_0.sky130_hd_inv_1_37.Y uo_out[7] uo_out[7] sky130_fd_pr__nfet_01v8 ad=0.0878 pd=0.92 as=0.169 ps=1.82 w=0.65 l=0.15
X467 a_28395_3800# a_28188_3741# a_28571_3523# VDPWR sky130_fd_pr__pfet_01v8_hvt ad=0.0683 pd=0.745 as=0.0767 ps=0.785 w=0.42 l=0.15
X468 VDPWR sky130_hd_ro32_nand_0.sky130_hd_inv_1_11.Y sky130_hd_ro32_nand_0.sky130_hd_inv_1_10.Y VDPWR sky130_fd_pr__pfet_01v8 ad=0.26 pd=2.52 as=0.135 ps=1.27 w=1 l=0.15
X469 sky130_hd_ro32_nand_0.sky130_hd_inv_1_20.Y sky130_hd_ro32_nand_0.sky130_hd_inv_1_21.Y VDPWR VDPWR sky130_fd_pr__pfet_01v8 ad=0.135 pd=1.27 as=0.26 ps=2.52 w=1 l=0.15
X470 sky130_hd_ro41_nand_0.sky130_hd_inv_1_31.Y sky130_hd_ro41_nand_0.sky130_hd_inv_1_32.Y uo_out[7] uo_out[7] sky130_fd_pr__nfet_01v8 ad=0.0878 pd=0.92 as=0.169 ps=1.82 w=0.65 l=0.15
X471 uo_out[7] a_27999_2003# a_27957_1891# uo_out[7] sky130_fd_pr__nfet_01v8 ad=0.121 pd=1.09 as=0.0696 ps=0.765 w=0.42 l=0.15
X472 uo_out[7] sky130_hd_ro33_nand_0.sky130_hd_inv_1_22.Y sky130_hd_ro33_nand_0.sky130_hd_inv_1_21.Y uo_out[7] sky130_fd_pr__nfet_01v8 ad=0.169 pd=1.82 as=0.0878 ps=0.92 w=0.65 l=0.15
X473 a_21261_33268# sky130_hd_xor_block_2.sky130_hd_xor2_1_0.B a_21179_33268# VDPWR sky130_fd_pr__pfet_01v8 ad=0.135 pd=1.27 as=0.26 ps=2.52 w=1 l=0.15
X474 VDPWR sky130_hd_ro47_nand_0.sky130_hd_inv_1_16.Y sky130_hd_ro47_nand_0.sky130_hd_inv_1_5.Y VDPWR sky130_fd_pr__pfet_01v8 ad=0.26 pd=2.52 as=0.135 ps=1.27 w=1 l=0.15
X475 sky130_hd_ro53_nand_0.sky130_hd_inv_1_41.A sky130_hd_ro53_nand_0.sky130_hd_inv_1_42.Y uo_out[7] uo_out[7] sky130_fd_pr__nfet_01v8 ad=0.0878 pd=0.92 as=0.169 ps=1.82 w=0.65 l=0.15
X476 VDPWR sky130_hd_ro33_nand_0.sky130_hd_inv_1_13.Y sky130_hd_ro33_nand_0.sky130_hd_inv_1_12.Y VDPWR sky130_fd_pr__pfet_01v8 ad=0.26 pd=2.52 as=0.135 ps=1.27 w=1 l=0.15
X477 sky130_hd_ro41_nand_0.sky130_hd_inv_1_5.A sky130_hd_ro41_nand_0.sky130_hd_inv_1_4.A VDPWR VDPWR sky130_fd_pr__pfet_01v8 ad=0.135 pd=1.27 as=0.26 ps=2.52 w=1 l=0.15
X478 sky130_hd_ro41_nand_0.sky130_hd_inv_1_5.A sky130_hd_ro41_nand_0.sky130_hd_inv_1_4.A uo_out[7] uo_out[7] sky130_fd_pr__nfet_01v8 ad=0.0878 pd=0.92 as=0.169 ps=1.82 w=0.65 l=0.15
X479 sky130_hd_ro47_nand_0.sky130_hd_inv_1_42.Y sky130_hd_ro47_nand_0.sky130_hd_inv_1_43.Y VDPWR VDPWR sky130_fd_pr__pfet_01v8 ad=0.135 pd=1.27 as=0.26 ps=2.52 w=1 l=0.15
X480 VDPWR a_28256_3345# a_28424_3247# VDPWR sky130_fd_pr__pfet_01v8_hvt ad=0.135 pd=1.27 as=0.27 ps=2.54 w=1 l=0.15
X481 sky130_hd_div_by_2_3.Qb a_28855_3301# uo_out[7] uo_out[7] sky130_fd_pr__nfet_01v8 ad=0.169 pd=1.82 as=0.097 ps=0.975 w=0.65 l=0.15
X482 VDPWR sky130_hd_xor_block_2.sky130_hd_xor2_1_0.B a_21429_33268# VDPWR sky130_fd_pr__pfet_01v8 ad=0.26 pd=2.52 as=0.135 ps=1.27 w=1 l=0.15
X483 uo_out[7] sky130_hd_ro32_nand_0.sky130_hd_inv_1_1.Y ua[0] uo_out[7] sky130_fd_pr__nfet_01v8 ad=0.169 pd=1.82 as=0.0878 ps=0.92 w=0.65 l=0.15
X484 sky130_hd_ro37_nand_0.sky130_hd_inv_1_21.Y sky130_hd_ro37_nand_0.sky130_hd_inv_1_22.Y VDPWR VDPWR sky130_fd_pr__pfet_01v8 ad=0.135 pd=1.27 as=0.26 ps=2.52 w=1 l=0.15
X485 a_27903_2667# a_28195_2557# a_28146_2435# VDPWR sky130_fd_pr__pfet_01v8_hvt ad=0.0567 pd=0.69 as=0.0882 ps=0.84 w=0.42 l=0.15
X486 a_28571_3523# a_28324_3901# VDPWR VDPWR sky130_fd_pr__pfet_01v8_hvt ad=0.0767 pd=0.785 as=0.179 ps=1.26 w=0.42 l=0.15
X487 sky130_hd_ro32_nand_0.sky130_hd_inv_1_17.Y sky130_hd_ro32_nand_0.sky130_hd_inv_1_18.Y VDPWR VDPWR sky130_fd_pr__pfet_01v8 ad=0.135 pd=1.27 as=0.26 ps=2.52 w=1 l=0.15
X488 uo_out[7] sky130_hd_div_by_2_1.Qb a_28742_1725# uo_out[7] sky130_fd_pr__nfet_01v8 ad=0.109 pd=1.36 as=0.0813 ps=0.83 w=0.42 l=0.15
X489 sky130_hd_ro53_nand_0.sky130_hd_inv_1_45.Y sky130_hd_ro53_nand_0.sky130_hd_inv_1_46.Y uo_out[7] uo_out[7] sky130_fd_pr__nfet_01v8 ad=0.0878 pd=0.92 as=0.169 ps=1.82 w=0.65 l=0.15
X490 sky130_hd_ro41_nand_0.sky130_hd_inv_1_36.Y sky130_hd_ro41_nand_0.sky130_hd_inv_1_37.Y VDPWR VDPWR sky130_fd_pr__pfet_01v8 ad=0.135 pd=1.27 as=0.26 ps=2.52 w=1 l=0.15
X491 sky130_hd_ro41_nand_0.sky130_hd_inv_1_36.Y sky130_hd_ro41_nand_0.sky130_hd_inv_1_37.Y uo_out[7] uo_out[7] sky130_fd_pr__nfet_01v8 ad=0.0878 pd=0.92 as=0.169 ps=1.82 w=0.65 l=0.15
X492 VDPWR sky130_hd_ro53_nand_0.sky130_hd_inv_1_37.Y sky130_hd_ro53_nand_0.sky130_hd_inv_1_36.Y VDPWR sky130_fd_pr__pfet_01v8 ad=0.26 pd=2.52 as=0.135 ps=1.27 w=1 l=0.15
X493 sky130_hd_ro37_nand_0.sky130_hd_inv_1_29.Y sky130_hd_ro37_nand_0.sky130_hd_inv_1_30.Y uo_out[7] uo_out[7] sky130_fd_pr__nfet_01v8 ad=0.0878 pd=0.92 as=0.169 ps=1.82 w=0.65 l=0.15
X494 uo_out[7] sky130_hd_ro37_nand_0.sky130_hd_inv_1_4.A sky130_hd_ro37_nand_0.sky130_hd_inv_1_5.A uo_out[7] sky130_fd_pr__nfet_01v8 ad=0.169 pd=1.82 as=0.0878 ps=0.92 w=0.65 l=0.15
X495 sky130_hd_ro53_nand_0.sky130_hd_inv_1_27.Y sky130_hd_ro53_nand_0.sky130_hd_inv_1_28.Y VDPWR VDPWR sky130_fd_pr__pfet_01v8 ad=0.135 pd=1.27 as=0.26 ps=2.52 w=1 l=0.15
X496 VDPWR sky130_hd_ro47_nand_0.sky130_hd_inv_1_25.Y sky130_hd_ro47_nand_0.sky130_hd_inv_1_24.Y VDPWR sky130_fd_pr__pfet_01v8 ad=0.26 pd=2.52 as=0.135 ps=1.27 w=1 l=0.15
X497 a_27631_2762# a_27903_2667# VDPWR VDPWR sky130_fd_pr__pfet_01v8_hvt ad=0.27 pd=2.54 as=0.135 ps=1.27 w=1 l=0.15
X498 VDPWR a_28256_2257# a_28424_2159# VDPWR sky130_fd_pr__pfet_01v8_hvt ad=0.135 pd=1.27 as=0.27 ps=2.54 w=1 l=0.15
X499 uo_out[7] sky130_hd_div_by_2_4.Q a_27392_2979# uo_out[7] sky130_fd_pr__nfet_01v8 ad=0.0567 pd=0.69 as=0.109 ps=1.36 w=0.42 l=0.15
X500 a_28395_3800# a_28195_3645# a_28544_3889# uo_out[7] sky130_fd_pr__special_nfet_01v8 ad=0.0621 pd=0.705 as=0.0696 ps=0.765 w=0.36 l=0.15
X501 sky130_hd_ro33_nand_0.sky130_hd_inv_1_11.Y sky130_hd_ro33_nand_0.sky130_hd_inv_1_12.Y VDPWR VDPWR sky130_fd_pr__pfet_01v8 ad=0.135 pd=1.27 as=0.26 ps=2.52 w=1 l=0.15
X502 sky130_hd_ro47_nand_0.sky130_hd_inv_1_30.Y sky130_hd_ro47_nand_0.sky130_hd_inv_1_31.Y uo_out[7] uo_out[7] sky130_fd_pr__nfet_01v8 ad=0.0878 pd=0.92 as=0.169 ps=1.82 w=0.65 l=0.15
X503 sky130_hd_ro47_nand_0.sky130_hd_inv_1_10.A sky130_hd_ro47_nand_0.sky130_hd_inv_1_9.A uo_out[7] uo_out[7] sky130_fd_pr__nfet_01v8 ad=0.0878 pd=0.92 as=0.169 ps=1.82 w=0.65 l=0.15
X504 sky130_hd_div_by_2_0.Qb a_28855_2213# uo_out[7] uo_out[7] sky130_fd_pr__nfet_01v8 ad=0.169 pd=1.82 as=0.097 ps=0.975 w=0.65 l=0.15
X505 uo_out[7] sky130_hd_ro53_nand_0.sky130_hd_inv_1_21.A sky130_hd_ro53_nand_0.sky130_hd_inv_1_22.A uo_out[7] sky130_fd_pr__nfet_01v8 ad=0.169 pd=1.82 as=0.0878 ps=0.92 w=0.65 l=0.15
X506 sky130_hd_xor_block_0.XORB sky130_hd_ro53_nand_0.sky130_hd_inv_1_1.Y VDPWR VDPWR sky130_fd_pr__pfet_01v8 ad=0.135 pd=1.27 as=0.26 ps=2.52 w=1 l=0.15
X507 a_24081_35929# a_23743_35715# VDPWR VDPWR sky130_fd_pr__pfet_01v8_hvt ad=0.0882 pd=0.84 as=0.111 ps=1.37 w=0.42 l=0.15
X508 VDPWR sky130_hd_ro41_nand_0.sky130_hd_inv_1_6.A sky130_hd_ro41_nand_0.sky130_hd_inv_1_7.A VDPWR sky130_fd_pr__pfet_01v8 ad=0.26 pd=2.52 as=0.135 ps=1.27 w=1 l=0.15
X509 uo_out[7] sky130_hd_ro41_nand_0.sky130_hd_inv_1_6.A sky130_hd_ro41_nand_0.sky130_hd_inv_1_7.A uo_out[7] sky130_fd_pr__nfet_01v8 ad=0.169 pd=1.82 as=0.0878 ps=0.92 w=0.65 l=0.15
X510 uo_out[7] sky130_hd_ro32_nand_0.sky130_hd_inv_1_28.Y sky130_hd_ro32_nand_0.sky130_hd_inv_1_27.Y uo_out[7] sky130_fd_pr__nfet_01v8 ad=0.169 pd=1.82 as=0.0878 ps=0.92 w=0.65 l=0.15
X511 sky130_hd_ro53_nand_0.sky130_hd_inv_1_50.Y sky130_hd_ro53_nand_0.sky130_hd_inv_1_51.Y uo_out[7] uo_out[7] sky130_fd_pr__nfet_01v8 ad=0.0878 pd=0.92 as=0.169 ps=1.82 w=0.65 l=0.15
X512 VDPWR sky130_hd_ro47_nand_0.sky130_hd_inv_1_29.Y sky130_hd_ro47_nand_0.sky130_hd_inv_1_28.Y VDPWR sky130_fd_pr__pfet_01v8 ad=0.26 pd=2.52 as=0.135 ps=1.27 w=1 l=0.15
X513 VDPWR sky130_hd_ro53_nand_0.sky130_hd_inv_1_41.A sky130_hd_ro53_nand_0.sky130_hd_inv_1_41.Y VDPWR sky130_fd_pr__pfet_01v8 ad=0.26 pd=2.52 as=0.135 ps=1.27 w=1 l=0.15
X514 uo_out[7] sky130_hd_ro53_nand_0.sky130_hd_inv_1_44.Y sky130_hd_ro53_nand_0.sky130_hd_inv_1_43.Y uo_out[7] sky130_fd_pr__nfet_01v8 ad=0.169 pd=1.82 as=0.0878 ps=0.92 w=0.65 l=0.15
X515 sky130_hd_ro37_nand_0.sky130_hd_inv_1_33.Y sky130_hd_ro37_nand_0.sky130_hd_inv_1_34.Y VDPWR VDPWR sky130_fd_pr__pfet_01v8 ad=0.135 pd=1.27 as=0.26 ps=2.52 w=1 l=0.15
X516 VDPWR sky130_hd_ro41_nand_0.sky130_hd_inv_1_2.A sky130_hd_ro41_nand_0.sky130_hd_inv_1_3.A VDPWR sky130_fd_pr__pfet_01v8 ad=0.26 pd=2.52 as=0.135 ps=1.27 w=1 l=0.15
X517 uo_out[7] sky130_hd_ro41_nand_0.sky130_hd_inv_1_2.A sky130_hd_ro41_nand_0.sky130_hd_inv_1_3.A uo_out[7] sky130_fd_pr__nfet_01v8 ad=0.169 pd=1.82 as=0.0878 ps=0.92 w=0.65 l=0.15
X518 sky130_hd_xor_block_1.sky130_hd_xor2_1_0.B sky130_hd_xor_block_1.sky130_hd_inv_1_3.A VDPWR VDPWR sky130_fd_pr__pfet_01v8 ad=0.135 pd=1.27 as=0.26 ps=2.52 w=1 l=0.15
X519 VDPWR sky130_hd_ro47_nand_0.sky130_hd_inv_1_3.Y sky130_hd_ro47_nand_0.sky130_hd_inv_1_2.Y VDPWR sky130_fd_pr__pfet_01v8 ad=0.26 pd=2.52 as=0.135 ps=1.27 w=1 l=0.15
X520 uo_out[7] sky130_hd_div_by_2_2.Q a_27392_1891# uo_out[7] sky130_fd_pr__nfet_01v8 ad=0.0567 pd=0.69 as=0.109 ps=1.36 w=0.42 l=0.15
X521 a_28146_1347# a_27631_1674# VDPWR VDPWR sky130_fd_pr__pfet_01v8_hvt ad=0.0882 pd=0.84 as=0.111 ps=1.37 w=0.42 l=0.15
X522 VDPWR sky130_hd_div_by_2_4.Q a_27392_2979# VDPWR sky130_fd_pr__pfet_01v8_hvt ad=0.0864 pd=0.91 as=0.166 ps=1.8 w=0.64 l=0.15
X523 a_28742_3901# a_28188_3741# a_28395_3800# uo_out[7] sky130_fd_pr__special_nfet_01v8 ad=0.0813 pd=0.83 as=0.0621 ps=0.705 w=0.36 l=0.15
X524 uo_out[7] sky130_hd_ro37_nand_0.sky130_hd_inv_1_28.Y sky130_hd_ro37_nand_0.sky130_hd_inv_1_27.Y uo_out[7] sky130_fd_pr__nfet_01v8 ad=0.169 pd=1.82 as=0.0878 ps=0.92 w=0.65 l=0.15
X525 VDPWR sky130_hd_ro53_nand_0.sky130_hd_inv_1_45.Y sky130_hd_ro53_nand_0.sky130_hd_inv_1_44.Y VDPWR sky130_fd_pr__pfet_01v8 ad=0.26 pd=2.52 as=0.135 ps=1.27 w=1 l=0.15
X526 uo_out[7] sky130_hd_ro32_nand_0.sky130_hd_inv_1_25.Y sky130_hd_ro32_nand_0.sky130_hd_inv_1_24.Y uo_out[7] sky130_fd_pr__nfet_01v8 ad=0.169 pd=1.82 as=0.0878 ps=0.92 w=0.65 l=0.15
X527 uo_out[7] sky130_hd_ro53_nand_0.sky130_hd_inv_1_16.A sky130_hd_ro53_nand_0.sky130_hd_inv_1_17.A uo_out[7] sky130_fd_pr__nfet_01v8 ad=0.169 pd=1.82 as=0.0878 ps=0.92 w=0.65 l=0.15
X528 sky130_hd_ro33_nand_0.sky130_hd_inv_1_3.Y sky130_hd_ro33_nand_0.sky130_hd_inv_1_4.Y VDPWR VDPWR sky130_fd_pr__pfet_01v8 ad=0.135 pd=1.27 as=0.26 ps=2.52 w=1 l=0.15
X529 sky130_hd_ro33_nand_0.sky130_hd_inv_1_29.Y sky130_hd_ro33_nand_0.sky130_hd_inv_1_30.Y uo_out[7] uo_out[7] sky130_fd_pr__nfet_01v8 ad=0.0878 pd=0.92 as=0.169 ps=1.82 w=0.65 l=0.15
X530 uo_out[7] sky130_hd_ro47_nand_0.sky130_hd_inv_1_11.A sky130_hd_ro47_nand_0.sky130_hd_inv_1_12.A uo_out[7] sky130_fd_pr__nfet_01v8 ad=0.169 pd=1.82 as=0.0878 ps=0.92 w=0.65 l=0.15
X531 a_28544_1713# a_28324_1725# uo_out[7] uo_out[7] sky130_fd_pr__nfet_01v8 ad=0.0696 pd=0.765 as=0.121 ps=1.09 w=0.42 l=0.15
X532 VDPWR sky130_hd_ro33_nand_0.sky130_hd_inv_1_31.Y sky130_hd_ro33_nand_0.sky130_hd_inv_1_30.Y VDPWR sky130_fd_pr__pfet_01v8 ad=0.26 pd=2.52 as=0.135 ps=1.27 w=1 l=0.15
X533 VDPWR sky130_hd_ro37_nand_0.sky130_hd_inv_1_5.A sky130_hd_ro37_nand_0.sky130_hd_inv_1_6.A VDPWR sky130_fd_pr__pfet_01v8 ad=0.26 pd=2.52 as=0.135 ps=1.27 w=1 l=0.15
X534 sky130_hd_ro47_nand_0.sky130_hd_inv_1_38.Y sky130_hd_ro47_nand_0.sky130_hd_inv_1_39.Y uo_out[7] uo_out[7] sky130_fd_pr__nfet_01v8 ad=0.0878 pd=0.92 as=0.169 ps=1.82 w=0.65 l=0.15
X535 VDPWR sky130_hd_xor_block_2.XORB sky130_hd_xor_block_2.sky130_hd_inv_1_1.Y VDPWR sky130_fd_pr__pfet_01v8 ad=0.26 pd=2.52 as=0.135 ps=1.27 w=1 l=0.15
X536 uo_out[7] sky130_hd_ro37_nand_0.sky130_hd_inv_1_17.Y sky130_hd_ro37_nand_0.sky130_hd_inv_1_16.Y uo_out[7] sky130_fd_pr__nfet_01v8 ad=0.169 pd=1.82 as=0.0878 ps=0.92 w=0.65 l=0.15
X537 uo_out[7] sky130_hd_ro32_nand_0.sky130_hd_inv_1_22.Y sky130_hd_ro32_nand_0.sky130_hd_inv_1_21.Y uo_out[7] sky130_fd_pr__nfet_01v8 ad=0.169 pd=1.82 as=0.0878 ps=0.92 w=0.65 l=0.15
X538 a_22016_35929# a_21678_35715# VDPWR VDPWR sky130_fd_pr__pfet_01v8_hvt ad=0.0882 pd=0.84 as=0.111 ps=1.37 w=0.42 l=0.15
X539 uo_out[7] sky130_hd_ro47_nand_0.sky130_hd_inv_1_7.A sky130_hd_ro47_nand_0.sky130_hd_inv_1_8.A uo_out[7] sky130_fd_pr__nfet_01v8 ad=0.169 pd=1.82 as=0.0878 ps=0.92 w=0.65 l=0.15
X540 VDPWR sky130_hd_ro32_nand_0.sky130_hd_inv_1_29.Y sky130_hd_ro32_nand_0.sky130_hd_inv_1_28.Y VDPWR sky130_fd_pr__pfet_01v8 ad=0.26 pd=2.52 as=0.135 ps=1.27 w=1 l=0.15
X541 a_21678_35715# a_21774_35537# VDPWR VDPWR sky130_fd_pr__pfet_01v8_hvt ad=0.27 pd=2.54 as=0.135 ps=1.27 w=1 l=0.15
X542 VDPWR sky130_hd_ro33_nand_0.sky130_hd_inv_1_15.Y sky130_hd_ro33_nand_0.sky130_hd_inv_1_14.Y VDPWR sky130_fd_pr__pfet_01v8 ad=0.26 pd=2.52 as=0.135 ps=1.27 w=1 l=0.15
X543 VDPWR sky130_hd_ro47_nand_0.sky130_hd_inv_1_22.Y sky130_hd_ro47_nand_0.sky130_hd_inv_1_21.Y VDPWR sky130_fd_pr__pfet_01v8 ad=0.26 pd=2.52 as=0.135 ps=1.27 w=1 l=0.15
X544 a_28340_2257# a_27558_1891# a_28256_2257# VDPWR sky130_fd_pr__pfet_01v8_hvt ad=0.0882 pd=0.84 as=0.0567 ps=0.69 w=0.42 l=0.15
X545 sky130_hd_ro32_nand_0.sky130_hd_inv_1_30.Y sky130_hd_ro32_nand_0.sky130_hd_inv_1_31.Y uo_out[7] uo_out[7] sky130_fd_pr__nfet_01v8 ad=0.0878 pd=0.92 as=0.169 ps=1.82 w=0.65 l=0.15
X546 VDPWR a_22265_35537# a_22194_35563# VDPWR sky130_fd_pr__pfet_01v8_hvt ad=0.179 pd=1.26 as=0.109 ps=1.08 w=0.75 l=0.15
X547 sky130_hd_ro33_nand_0.sky130_hd_inv_1_8.Y sky130_hd_ro33_nand_0.sky130_hd_inv_1_9.Y VDPWR VDPWR sky130_fd_pr__pfet_01v8 ad=0.135 pd=1.27 as=0.26 ps=2.52 w=1 l=0.15
X548 sky130_hd_ro47_nand_0.sky130_hd_inv_1_13.A sky130_hd_ro47_nand_0.sky130_hd_inv_1_12.A uo_out[7] uo_out[7] sky130_fd_pr__nfet_01v8 ad=0.0878 pd=0.92 as=0.169 ps=1.82 w=0.65 l=0.15
X549 uo_out[7] sky130_hd_ro53_nand_0.sky130_hd_inv_1_11.Y sky130_hd_ro53_nand_0.sky130_hd_inv_1_10.Y uo_out[7] sky130_fd_pr__nfet_01v8 ad=0.169 pd=1.82 as=0.0878 ps=0.92 w=0.65 l=0.15
X550 VDPWR sky130_hd_ro41_nand_0.sky130_hd_inv_1_9.A sky130_hd_ro41_nand_0.sky130_hd_inv_1_10.A VDPWR sky130_fd_pr__pfet_01v8 ad=0.26 pd=2.52 as=0.135 ps=1.27 w=1 l=0.15
X551 uo_out[7] sky130_hd_ro41_nand_0.sky130_hd_inv_1_9.A sky130_hd_ro41_nand_0.sky130_hd_inv_1_10.A uo_out[7] sky130_fd_pr__nfet_01v8 ad=0.169 pd=1.82 as=0.0878 ps=0.92 w=0.65 l=0.15
X552 uo_out[7] sky130_hd_ro32_nand_0.sky130_hd_inv_1_19.Y sky130_hd_ro32_nand_0.sky130_hd_inv_1_18.Y uo_out[7] sky130_fd_pr__nfet_01v8 ad=0.169 pd=1.82 as=0.0878 ps=0.92 w=0.65 l=0.15
X553 a_19695_33932# sky130_hd_xor_block_3.sky130_hd_xor2_1_0.A VDPWR VDPWR sky130_fd_pr__pfet_01v8 ad=0.135 pd=1.27 as=0.135 ps=1.27 w=1 l=0.15
X554 uo_out[7] sky130_hd_ro47_nand_0.sky130_hd_inv_1_21.Y sky130_hd_ro47_nand_0.sky130_hd_inv_1_20.Y uo_out[7] sky130_fd_pr__nfet_01v8 ad=0.169 pd=1.82 as=0.0878 ps=0.92 w=0.65 l=0.15
X555 VDPWR sky130_hd_ro32_nand_0.sky130_hd_inv_1_26.Y sky130_hd_ro32_nand_0.sky130_hd_inv_1_25.Y VDPWR sky130_fd_pr__pfet_01v8 ad=0.26 pd=2.52 as=0.135 ps=1.27 w=1 l=0.15
X556 a_27536_1321# a_27631_1674# uo_out[7] uo_out[7] sky130_fd_pr__nfet_01v8 ad=0.109 pd=1.36 as=0.097 ps=0.975 w=0.42 l=0.15
X557 sky130_hd_ro33_nand_0.sky130_hd_inv_1_12.Y sky130_hd_ro33_nand_0.sky130_hd_inv_1_13.Y VDPWR VDPWR sky130_fd_pr__pfet_01v8 ad=0.135 pd=1.27 as=0.26 ps=2.52 w=1 l=0.15
X558 sky130_hd_ro53_nand_0.sky130_hd_inv_1_32.Y sky130_hd_ro53_nand_0.sky130_hd_inv_1_33.Y VDPWR VDPWR sky130_fd_pr__pfet_01v8 ad=0.135 pd=1.27 as=0.26 ps=2.52 w=1 l=0.15
X559 a_28324_2813# a_28195_2557# a_27903_2667# uo_out[7] sky130_fd_pr__special_nfet_01v8 ad=0.0989 pd=0.995 as=0.0684 ps=0.74 w=0.36 l=0.15
X560 a_28324_1725# a_28188_1565# a_27903_1579# VDPWR sky130_fd_pr__pfet_01v8_hvt ad=0.109 pd=1.08 as=0.0567 ps=0.69 w=0.42 l=0.15
X561 a_24677_35563# a_24123_35537# a_24330_35537# uo_out[7] sky130_fd_pr__special_nfet_01v8 ad=0.0813 pd=0.83 as=0.0621 ps=0.705 w=0.36 l=0.15
X562 a_21429_33268# sky130_hd_xor_block_2.sky130_hd_xor2_1_0.A VDPWR VDPWR sky130_fd_pr__pfet_01v8 ad=0.135 pd=1.27 as=0.135 ps=1.27 w=1 l=0.15
X563 sky130_hd_ro32_nand_0.sky130_hd_inv_1_3.Y sky130_hd_ro32_nand_0.sky130_hd_inv_1_4.Y VDPWR VDPWR sky130_fd_pr__pfet_01v8 ad=0.135 pd=1.27 as=0.26 ps=2.52 w=1 l=0.15
X564 uo_out[7] sky130_hd_xor_block_0.sky130_hd_inv_1_1.Y sky130_hd_xor_block_0.sky130_hd_xor2_1_0.A uo_out[7] sky130_fd_pr__nfet_01v8 ad=0.169 pd=1.82 as=0.0878 ps=0.92 w=0.65 l=0.15
X565 VDPWR sky130_hd_ro47_nand_0.sky130_hd_nand2_1_0.Y sky130_hd_ro47_nand_0.sky130_hd_inv_1_45.Y VDPWR sky130_fd_pr__pfet_01v8 ad=0.26 pd=2.52 as=0.135 ps=1.27 w=1 l=0.15
X566 VDPWR sky130_hd_ro47_nand_0.sky130_hd_inv_1_27.Y sky130_hd_ro47_nand_0.sky130_hd_inv_1_26.Y VDPWR sky130_fd_pr__pfet_01v8 ad=0.26 pd=2.52 as=0.135 ps=1.27 w=1 l=0.15
X567 VDPWR sky130_hd_ro37_nand_0.sky130_hd_inv_1_25.Y sky130_hd_ro37_nand_0.sky130_hd_inv_1_24.Y VDPWR sky130_fd_pr__pfet_01v8 ad=0.26 pd=2.52 as=0.135 ps=1.27 w=1 l=0.15
X568 uo_out[7] sky130_hd_ro53_nand_0.sky130_hd_inv_1_19.A sky130_hd_ro53_nand_0.sky130_hd_inv_1_20.A uo_out[7] sky130_fd_pr__nfet_01v8 ad=0.169 pd=1.82 as=0.0878 ps=0.92 w=0.65 l=0.15
X569 sky130_hd_ro37_nand_0.sky130_hd_inv_1_5.A sky130_hd_ro37_nand_0.sky130_hd_inv_1_4.A uo_out[7] uo_out[7] sky130_fd_pr__nfet_01v8 ad=0.0878 pd=0.92 as=0.169 ps=1.82 w=0.65 l=0.15
X570 VDPWR sky130_hd_ro41_nand_0.sky130_hd_inv_1_21.Y sky130_hd_ro41_nand_0.sky130_hd_inv_1_20.Y VDPWR sky130_fd_pr__pfet_01v8 ad=0.26 pd=2.52 as=0.135 ps=1.27 w=1 l=0.15
X571 uo_out[7] sky130_hd_ro53_nand_0.sky130_hd_inv_1_30.Y sky130_hd_ro53_nand_0.sky130_hd_inv_1_29.Y uo_out[7] sky130_fd_pr__nfet_01v8 ad=0.169 pd=1.82 as=0.0878 ps=0.92 w=0.65 l=0.15
X572 uo_out[7] sky130_hd_ro41_nand_0.sky130_hd_inv_1_21.Y sky130_hd_ro41_nand_0.sky130_hd_inv_1_20.Y uo_out[7] sky130_fd_pr__nfet_01v8 ad=0.169 pd=1.82 as=0.0878 ps=0.92 w=0.65 l=0.15
X573 ua[0] sky130_hd_ro32_nand_0.sky130_hd_inv_1_1.Y VDPWR VDPWR sky130_fd_pr__pfet_01v8 ad=0.135 pd=1.27 as=0.26 ps=2.52 w=1 l=0.15
X574 sky130_hd_ro37_nand_0.sky130_hd_inv_1_34.Y sky130_hd_ro37_nand_0.sky130_hd_inv_1_35.Y VDPWR VDPWR sky130_fd_pr__pfet_01v8 ad=0.135 pd=1.27 as=0.26 ps=2.52 w=1 l=0.15
X575 uo_out[7] sky130_hd_ro37_nand_0.sky130_hd_inv_1_14.Y sky130_hd_ro37_nand_0.sky130_hd_inv_1_13.Y uo_out[7] sky130_fd_pr__nfet_01v8 ad=0.169 pd=1.82 as=0.0878 ps=0.92 w=0.65 l=0.15
X576 VDPWR sky130_hd_xor_block_1.XORB sky130_hd_xor_block_1.sky130_hd_inv_1_1.Y VDPWR sky130_fd_pr__pfet_01v8 ad=0.26 pd=2.52 as=0.135 ps=1.27 w=1 l=0.15
X577 VDPWR sky130_hd_ro41_nand_0.sky130_hd_inv_1_25.Y sky130_hd_ro41_nand_0.sky130_hd_inv_1_24.Y VDPWR sky130_fd_pr__pfet_01v8 ad=0.26 pd=2.52 as=0.135 ps=1.27 w=1 l=0.15
X578 VDPWR sky130_hd_ro53_nand_0.sky130_hd_inv_1_47.Y sky130_hd_ro53_nand_0.sky130_hd_inv_1_46.Y VDPWR sky130_fd_pr__pfet_01v8 ad=0.26 pd=2.52 as=0.135 ps=1.27 w=1 l=0.15
X579 sky130_hd_ro53_nand_0.sky130_hd_inv_1_40.Y sky130_hd_ro53_nand_0.sky130_hd_inv_1_41.Y uo_out[7] uo_out[7] sky130_fd_pr__nfet_01v8 ad=0.0878 pd=0.92 as=0.169 ps=1.82 w=0.65 l=0.15
X580 uo_out[7] sky130_hd_xor_block_3.sky130_hd_inv_1_3.A sky130_hd_xor_block_3.sky130_hd_xor2_1_0.B uo_out[7] sky130_fd_pr__nfet_01v8 ad=0.169 pd=1.82 as=0.0878 ps=0.92 w=0.65 l=0.15
X581 uo_out[7] sky130_hd_xor_block_1.XOROUT sky130_hd_xor_block_0.sky130_hd_inv_1_3.A uo_out[7] sky130_fd_pr__nfet_01v8 ad=0.169 pd=1.82 as=0.0878 ps=0.92 w=0.65 l=0.15
X582 uo_out[7] sky130_hd_ro41_nand_0.sky130_hd_inv_1_25.Y sky130_hd_ro41_nand_0.sky130_hd_inv_1_24.Y uo_out[7] sky130_fd_pr__nfet_01v8 ad=0.169 pd=1.82 as=0.0878 ps=0.92 w=0.65 l=0.15
X583 VDPWR sky130_hd_ro47_nand_0.sky130_hd_inv_1_19.Y sky130_hd_ro47_nand_0.sky130_hd_inv_1_18.Y VDPWR sky130_fd_pr__pfet_01v8 ad=0.26 pd=2.52 as=0.135 ps=1.27 w=1 l=0.15
X584 a_27536_1321# a_27631_1674# VDPWR VDPWR sky130_fd_pr__pfet_01v8_hvt ad=0.166 pd=1.8 as=0.154 ps=1.34 w=0.64 l=0.15
X585 sky130_hd_ro33_nand_0.sky130_hd_inv_1_5.Y sky130_hd_ro33_nand_0.sky130_hd_inv_1_6.Y VDPWR VDPWR sky130_fd_pr__pfet_01v8 ad=0.135 pd=1.27 as=0.26 ps=2.52 w=1 l=0.15
X586 sky130_hd_ro53_nand_0.sky130_hd_inv_1_41.Y sky130_hd_ro53_nand_0.sky130_hd_inv_1_41.A VDPWR VDPWR sky130_fd_pr__pfet_01v8 ad=0.135 pd=1.27 as=0.26 ps=2.52 w=1 l=0.15
X587 uo_out[7] sky130_hd_ro33_nand_0.sky130_hd_inv_1_8.Y sky130_hd_ro33_nand_0.sky130_hd_inv_1_7.Y uo_out[7] sky130_fd_pr__nfet_01v8 ad=0.169 pd=1.82 as=0.0878 ps=0.92 w=0.65 l=0.15
X588 sky130_hd_ro53_nand_0.sky130_hd_inv_1_43.Y sky130_hd_ro53_nand_0.sky130_hd_inv_1_44.Y uo_out[7] uo_out[7] sky130_fd_pr__nfet_01v8 ad=0.0878 pd=0.92 as=0.169 ps=1.82 w=0.65 l=0.15
X589 uo_out[7] sky130_hd_ro47_nand_0.sky130_hd_inv_1_18.Y sky130_hd_ro47_nand_0.sky130_hd_inv_1_7.A uo_out[7] sky130_fd_pr__nfet_01v8 ad=0.169 pd=1.82 as=0.0878 ps=0.92 w=0.65 l=0.15
X590 VDPWR a_22058_35537# a_22065_35837# VDPWR sky130_fd_pr__pfet_01v8_hvt ad=0.0864 pd=0.91 as=0.166 ps=1.8 w=0.64 l=0.15
X591 sky130_hd_ro47_nand_0.sky130_hd_inv_1_11.A sky130_hd_ro47_nand_0.sky130_hd_inv_1_10.A VDPWR VDPWR sky130_fd_pr__pfet_01v8 ad=0.135 pd=1.27 as=0.26 ps=2.52 w=1 l=0.15
X592 sky130_hd_ro37_nand_0.sky130_hd_inv_1_27.Y sky130_hd_ro37_nand_0.sky130_hd_inv_1_28.Y uo_out[7] uo_out[7] sky130_fd_pr__nfet_01v8 ad=0.0878 pd=0.92 as=0.169 ps=1.82 w=0.65 l=0.15
X593 sky130_hd_xor_block_2.sky130_hd_inv_1_3.A sky130_hd_xor_block_3.XOROUT VDPWR VDPWR sky130_fd_pr__pfet_01v8 ad=0.135 pd=1.27 as=0.26 ps=2.52 w=1 l=0.15
X594 VDPWR sky130_hd_ro47_nand_0.sky130_hd_inv_1_24.Y sky130_hd_ro47_nand_0.sky130_hd_inv_1_23.Y VDPWR sky130_fd_pr__pfet_01v8 ad=0.26 pd=2.52 as=0.135 ps=1.27 w=1 l=0.15
X595 sky130_hd_ro47_nand_0.sky130_hd_inv_1_12.A sky130_hd_ro47_nand_0.sky130_hd_inv_1_11.A uo_out[7] uo_out[7] sky130_fd_pr__nfet_01v8 ad=0.0878 pd=0.92 as=0.169 ps=1.82 w=0.65 l=0.15
X596 a_24677_35563# a_24130_35837# a_24330_35537# VDPWR sky130_fd_pr__pfet_01v8_hvt ad=0.0578 pd=0.695 as=0.0683 ps=0.745 w=0.42 l=0.15
X597 sky130_hd_ro33_nand_0.sky130_hd_inv_1_30.Y sky130_hd_ro33_nand_0.sky130_hd_inv_1_31.Y VDPWR VDPWR sky130_fd_pr__pfet_01v8 ad=0.135 pd=1.27 as=0.26 ps=2.52 w=1 l=0.15
X598 uo_out[7] sky130_hd_ro37_nand_0.sky130_hd_inv_1_1.A sky130_hd_ro37_nand_0.sky130_hd_inv_1_2.A uo_out[7] sky130_fd_pr__nfet_01v8 ad=0.169 pd=1.82 as=0.0878 ps=0.92 w=0.65 l=0.15
X599 sky130_hd_ro33_nand_0.sky130_hd_inv_1_23.Y sky130_hd_ro33_nand_0.sky130_hd_inv_1_24.Y VDPWR VDPWR sky130_fd_pr__pfet_01v8 ad=0.135 pd=1.27 as=0.26 ps=2.52 w=1 l=0.15
X600 uo_out[7] sky130_hd_ro32_nand_0.sky130_hd_inv_1_8.Y sky130_hd_ro32_nand_0.sky130_hd_inv_1_7.Y uo_out[7] sky130_fd_pr__nfet_01v8 ad=0.169 pd=1.82 as=0.0878 ps=0.92 w=0.65 l=0.15
X601 sky130_hd_xor_block_2.sky130_hd_xor2_1_0.B sky130_hd_xor_block_2.sky130_hd_inv_1_3.A uo_out[7] uo_out[7] sky130_fd_pr__nfet_01v8 ad=0.0878 pd=0.92 as=0.169 ps=1.82 w=0.65 l=0.15
X602 VDPWR sky130_hd_ro47_nand_0.sky130_hd_inv_1_28.Y sky130_hd_ro47_nand_0.sky130_hd_inv_1_27.Y VDPWR sky130_fd_pr__pfet_01v8 ad=0.26 pd=2.52 as=0.135 ps=1.27 w=1 l=0.15
X603 uo_out[7] sky130_hd_ro47_nand_0.sky130_hd_inv_1_23.Y sky130_hd_ro47_nand_0.sky130_hd_inv_1_22.Y uo_out[7] sky130_fd_pr__nfet_01v8 ad=0.169 pd=1.82 as=0.0878 ps=0.92 w=0.65 l=0.15
X604 uo_out[7] sky130_hd_xor_block_0.XOROUT a_24677_35563# uo_out[7] sky130_fd_pr__nfet_01v8 ad=0.109 pd=1.36 as=0.0813 ps=0.83 w=0.42 l=0.15
X605 sky130_hd_ro33_nand_0.sky130_hd_inv_1_14.Y sky130_hd_ro33_nand_0.sky130_hd_inv_1_15.Y VDPWR VDPWR sky130_fd_pr__pfet_01v8 ad=0.135 pd=1.27 as=0.26 ps=2.52 w=1 l=0.15
X606 sky130_hd_ro37_nand_0.sky130_hd_inv_1_31.Y sky130_hd_ro37_nand_0.sky130_hd_inv_1_32.Y VDPWR VDPWR sky130_fd_pr__pfet_01v8 ad=0.135 pd=1.27 as=0.26 ps=2.52 w=1 l=0.15
X607 uo_out[7] sky130_hd_ro37_nand_0.sky130_hd_inv_1_11.Y sky130_hd_ro37_nand_0.sky130_hd_inv_1_10.Y uo_out[7] sky130_fd_pr__nfet_01v8 ad=0.169 pd=1.82 as=0.0878 ps=0.92 w=0.65 l=0.15
X608 sky130_hd_ro47_nand_0.sky130_hd_inv_1_21.Y sky130_hd_ro47_nand_0.sky130_hd_inv_1_22.Y VDPWR VDPWR sky130_fd_pr__pfet_01v8 ad=0.135 pd=1.27 as=0.26 ps=2.52 w=1 l=0.15
X609 uo_out[7] sky130_hd_ro33_nand_0.sky130_hd_inv_1_17.Y sky130_hd_ro33_nand_0.sky130_hd_inv_1_16.Y uo_out[7] sky130_fd_pr__nfet_01v8 ad=0.169 pd=1.82 as=0.0878 ps=0.92 w=0.65 l=0.15
X610 VDPWR sky130_hd_ro47_nand_0.sky130_hd_inv_1_1.Y sky130_hd_xor_block_1.XORB VDPWR sky130_fd_pr__pfet_01v8 ad=0.26 pd=2.52 as=0.135 ps=1.27 w=1 l=0.15
X611 sky130_hd_ro53_nand_0.sky130_hd_inv_1_37.Y sky130_hd_ro53_nand_0.sky130_hd_inv_1_38.Y uo_out[7] uo_out[7] sky130_fd_pr__nfet_01v8 ad=0.0878 pd=0.92 as=0.169 ps=1.82 w=0.65 l=0.15
X612 VDPWR sky130_hd_ro41_nand_0.sky130_hd_inv_1_22.Y sky130_hd_ro41_nand_0.sky130_hd_inv_1_21.Y VDPWR sky130_fd_pr__pfet_01v8 ad=0.26 pd=2.52 as=0.135 ps=1.27 w=1 l=0.15
X613 sky130_hd_ro41_nand_0.sky130_hd_inv_1_10.A sky130_hd_ro41_nand_0.sky130_hd_inv_1_9.A VDPWR VDPWR sky130_fd_pr__pfet_01v8 ad=0.135 pd=1.27 as=0.26 ps=2.52 w=1 l=0.15
X614 uo_out[7] sky130_hd_ro41_nand_0.sky130_hd_inv_1_22.Y sky130_hd_ro41_nand_0.sky130_hd_inv_1_21.Y uo_out[7] sky130_fd_pr__nfet_01v8 ad=0.169 pd=1.82 as=0.0878 ps=0.92 w=0.65 l=0.15
X615 sky130_hd_ro41_nand_0.sky130_hd_inv_1_10.A sky130_hd_ro41_nand_0.sky130_hd_inv_1_9.A uo_out[7] uo_out[7] sky130_fd_pr__nfet_01v8 ad=0.0878 pd=0.92 as=0.169 ps=1.82 w=0.65 l=0.15
X616 uo_out[7] sky130_hd_ro32_nand_0.sky130_hd_inv_1_5.Y sky130_hd_ro32_nand_0.sky130_hd_inv_1_4.Y uo_out[7] sky130_fd_pr__nfet_01v8 ad=0.169 pd=1.82 as=0.0878 ps=0.92 w=0.65 l=0.15
X617 VDPWR sky130_hd_ro53_nand_0.sky130_hd_inv_1_1.Y sky130_hd_xor_block_0.XORB VDPWR sky130_fd_pr__pfet_01v8 ad=0.26 pd=2.52 as=0.135 ps=1.27 w=1 l=0.15
X618 VDPWR sky130_hd_ro37_nand_0.sky130_hd_inv_1_26.Y sky130_hd_ro37_nand_0.sky130_hd_inv_1_25.A VDPWR sky130_fd_pr__pfet_01v8 ad=0.26 pd=2.52 as=0.135 ps=1.27 w=1 l=0.15
X619 VDPWR sky130_hd_ro32_nand_0.sky130_hd_inv_1_12.Y sky130_hd_ro32_nand_0.sky130_hd_inv_1_11.Y VDPWR sky130_fd_pr__pfet_01v8 ad=0.26 pd=2.52 as=0.135 ps=1.27 w=1 l=0.15
X620 a_21774_35537# a_22058_35537# a_21993_35563# uo_out[7] sky130_fd_pr__special_nfet_01v8 ad=0.0684 pd=0.74 as=0.066 ps=0.745 w=0.36 l=0.15
X621 sky130_hd_ro47_nand_0.sky130_hd_inv_1_3.Y sky130_hd_ro47_nand_0.sky130_hd_inv_1_4.Y uo_out[7] uo_out[7] sky130_fd_pr__nfet_01v8 ad=0.0878 pd=0.92 as=0.169 ps=1.82 w=0.65 l=0.15
X622 sky130_hd_ro53_nand_0.sky130_hd_inv_1_38.Y sky130_hd_ro53_nand_0.sky130_hd_inv_1_39.Y VDPWR VDPWR sky130_fd_pr__pfet_01v8 ad=0.135 pd=1.27 as=0.26 ps=2.52 w=1 l=0.15
X623 VDPWR sky130_hd_div_by_2_4.Qb a_28742_3901# VDPWR sky130_fd_pr__pfet_01v8_hvt ad=0.109 pd=1.36 as=0.0578 ps=0.695 w=0.42 l=0.15
X624 sky130_hd_ro32_nand_0.sky130_hd_inv_1_14.Y sky130_hd_ro32_nand_0.sky130_hd_inv_1_15.Y uo_out[7] uo_out[7] sky130_fd_pr__nfet_01v8 ad=0.0878 pd=0.92 as=0.169 ps=1.82 w=0.65 l=0.15
X625 sky130_hd_xor_block_0.sky130_hd_xor2_1_0.A sky130_hd_xor_block_0.sky130_hd_inv_1_1.Y uo_out[7] uo_out[7] sky130_fd_pr__nfet_01v8 ad=0.0878 pd=0.92 as=0.169 ps=1.82 w=0.65 l=0.15
X626 sky130_hd_ro47_nand_0.sky130_hd_inv_1_26.Y sky130_hd_ro47_nand_0.sky130_hd_inv_1_27.Y VDPWR VDPWR sky130_fd_pr__pfet_01v8 ad=0.135 pd=1.27 as=0.26 ps=2.52 w=1 l=0.15
X627 uo_out[7] sky130_hd_ro32_nand_0.sky130_hd_inv_1_2.Y sky130_hd_ro32_nand_0.sky130_hd_inv_1_1.Y uo_out[7] sky130_fd_pr__nfet_01v8 ad=0.169 pd=1.82 as=0.0878 ps=0.92 w=0.65 l=0.15
X628 uo_out[7] sky130_hd_ro53_nand_0.sky130_hd_inv_1_5.Y sky130_hd_ro53_nand_0.sky130_hd_inv_1_4.Y uo_out[7] sky130_fd_pr__nfet_01v8 ad=0.169 pd=1.82 as=0.0878 ps=0.92 w=0.65 l=0.15
X629 VDPWR sky130_hd_ro41_nand_0.sky130_hd_inv_1_27.Y sky130_hd_ro41_nand_0.sky130_hd_inv_1_26.Y VDPWR sky130_fd_pr__pfet_01v8 ad=0.26 pd=2.52 as=0.135 ps=1.27 w=1 l=0.15
X630 a_28123_1713# a_27631_1674# uo_out[7] uo_out[7] sky130_fd_pr__nfet_01v8 ad=0.066 pd=0.745 as=0.109 ps=1.36 w=0.42 l=0.15
X631 VDPWR sky130_hd_ro32_nand_0.sky130_hd_inv_1_9.Y sky130_hd_ro32_nand_0.sky130_hd_inv_1_8.Y VDPWR sky130_fd_pr__pfet_01v8 ad=0.26 pd=2.52 as=0.135 ps=1.27 w=1 l=0.15
X632 uo_out[7] sky130_hd_ro41_nand_0.sky130_hd_inv_1_27.Y sky130_hd_ro41_nand_0.sky130_hd_inv_1_26.Y uo_out[7] sky130_fd_pr__nfet_01v8 ad=0.169 pd=1.82 as=0.0878 ps=0.92 w=0.65 l=0.15
X633 uo_out[7] sky130_hd_ro47_nand_0.sky130_hd_inv_1_35.A sky130_hd_ro47_nand_0.sky130_hd_inv_1_35.Y uo_out[7] sky130_fd_pr__nfet_01v8 ad=0.169 pd=1.82 as=0.0878 ps=0.92 w=0.65 l=0.15
X634 uo_out[7] sky130_hd_ro47_nand_0.sky130_hd_inv_1_8.A sky130_hd_ro47_nand_0.sky130_hd_inv_1_9.A uo_out[7] sky130_fd_pr__nfet_01v8 ad=0.169 pd=1.82 as=0.0878 ps=0.92 w=0.65 l=0.15
X635 VDPWR a_28395_2712# a_28324_2813# VDPWR sky130_fd_pr__pfet_01v8_hvt ad=0.179 pd=1.26 as=0.109 ps=1.08 w=0.75 l=0.15
X636 sky130_hd_ro41_nand_0.sky130_hd_inv_1_20.Y sky130_hd_ro41_nand_0.sky130_hd_inv_1_21.Y VDPWR VDPWR sky130_fd_pr__pfet_01v8 ad=0.135 pd=1.27 as=0.26 ps=2.52 w=1 l=0.15
X637 sky130_hd_ro47_nand_0.sky130_hd_inv_1_15.A sky130_hd_ro47_nand_0.sky130_hd_inv_1_14.A uo_out[7] uo_out[7] sky130_fd_pr__nfet_01v8 ad=0.0878 pd=0.92 as=0.169 ps=1.82 w=0.65 l=0.15
X638 VDPWR a_27536_3497# sky130_hd_div_by_2_4.Qb VDPWR sky130_fd_pr__pfet_01v8_hvt ad=0.154 pd=1.34 as=0.26 ps=2.52 w=1 l=0.15
X639 sky130_hd_ro32_nand_0.sky130_hd_inv_1_11.Y sky130_hd_ro32_nand_0.sky130_hd_inv_1_12.Y uo_out[7] uo_out[7] sky130_fd_pr__nfet_01v8 ad=0.0878 pd=0.92 as=0.169 ps=1.82 w=0.65 l=0.15
X640 sky130_hd_ro41_nand_0.sky130_hd_inv_1_20.Y sky130_hd_ro41_nand_0.sky130_hd_inv_1_21.Y uo_out[7] uo_out[7] sky130_fd_pr__nfet_01v8 ad=0.0878 pd=0.92 as=0.169 ps=1.82 w=0.65 l=0.15
X641 uo_out[7] sky130_hd_ro53_nand_0.sky130_hd_inv_1_9.Y sky130_hd_ro53_nand_0.sky130_hd_inv_1_8.Y uo_out[7] sky130_fd_pr__nfet_01v8 ad=0.169 pd=1.82 as=0.0878 ps=0.92 w=0.65 l=0.15
X642 uo_out[7] sky130_hd_ro33_nand_0.sky130_hd_inv_1_10.Y sky130_hd_ro33_nand_0.sky130_hd_inv_1_9.Y uo_out[7] sky130_fd_pr__nfet_01v8 ad=0.169 pd=1.82 as=0.0878 ps=0.92 w=0.65 l=0.15
X643 uo_out[7] sky130_hd_ro47_nand_0.sky130_hd_inv_1_20.Y sky130_hd_ro47_nand_0.sky130_hd_inv_1_19.Y uo_out[7] sky130_fd_pr__nfet_01v8 ad=0.169 pd=1.82 as=0.0878 ps=0.92 w=0.65 l=0.15
X644 a_28188_1565# sky130_hd_div_by_2_1.CLK VDPWR VDPWR sky130_fd_pr__pfet_01v8_hvt ad=0.166 pd=1.8 as=0.0864 ps=0.91 w=0.64 l=0.15
X645 sky130_hd_ro53_nand_0.sky130_hd_inv_1_46.Y sky130_hd_ro53_nand_0.sky130_hd_inv_1_47.Y VDPWR VDPWR sky130_fd_pr__pfet_01v8 ad=0.135 pd=1.27 as=0.26 ps=2.52 w=1 l=0.15
X646 a_27631_2762# a_27903_2667# uo_out[7] uo_out[7] sky130_fd_pr__nfet_01v8 ad=0.169 pd=1.82 as=0.0878 ps=0.92 w=0.65 l=0.15
X647 uo_out[7] sky130_hd_ro33_nand_0.sky130_hd_inv_1_14.Y sky130_hd_ro33_nand_0.sky130_hd_inv_1_13.Y uo_out[7] sky130_fd_pr__nfet_01v8 ad=0.169 pd=1.82 as=0.0878 ps=0.92 w=0.65 l=0.15
X648 sky130_hd_ro37_nand_0.sky130_hd_inv_1_28.Y sky130_hd_ro37_nand_0.sky130_hd_inv_1_29.Y VDPWR VDPWR sky130_fd_pr__pfet_01v8 ad=0.135 pd=1.27 as=0.26 ps=2.52 w=1 l=0.15
X649 uo_out[7] sky130_hd_ro32_nand_0.sky130_hd_inv_1_6.Y sky130_hd_ro32_nand_0.sky130_hd_inv_1_5.Y uo_out[7] sky130_fd_pr__nfet_01v8 ad=0.169 pd=1.82 as=0.0878 ps=0.92 w=0.65 l=0.15
X650 sky130_hd_ro53_nand_0.sky130_hd_inv_1_18.A sky130_hd_ro53_nand_0.sky130_hd_inv_1_17.A uo_out[7] uo_out[7] sky130_fd_pr__nfet_01v8 ad=0.0878 pd=0.92 as=0.169 ps=1.82 w=0.65 l=0.15
X651 sky130_hd_ro53_nand_0.sky130_hd_inv_1_35.Y sky130_hd_ro53_nand_0.sky130_hd_inv_1_36.Y VDPWR VDPWR sky130_fd_pr__pfet_01v8 ad=0.135 pd=1.27 as=0.26 ps=2.52 w=1 l=0.15
X652 a_23743_35715# a_23839_35537# VDPWR VDPWR sky130_fd_pr__pfet_01v8_hvt ad=0.27 pd=2.54 as=0.135 ps=1.27 w=1 l=0.15
X653 VDPWR a_24330_35537# a_24259_35563# VDPWR sky130_fd_pr__pfet_01v8_hvt ad=0.179 pd=1.26 as=0.109 ps=1.08 w=0.75 l=0.15
X654 sky130_hd_xor_block_3.sky130_hd_xor2_1_0.A sky130_hd_xor_block_3.sky130_hd_inv_1_1.Y VDPWR VDPWR sky130_fd_pr__pfet_01v8 ad=0.135 pd=1.27 as=0.26 ps=2.52 w=1 l=0.15
X655 sky130_hd_ro37_nand_0.sky130_hd_inv_1_6.A sky130_hd_ro37_nand_0.sky130_hd_inv_1_5.A uo_out[7] uo_out[7] sky130_fd_pr__nfet_01v8 ad=0.0878 pd=0.92 as=0.169 ps=1.82 w=0.65 l=0.15
X656 uo_out[7] sky130_hd_ro33_nand_0.sky130_hd_inv_1_28.Y sky130_hd_ro33_nand_0.sky130_hd_inv_1_27.Y uo_out[7] sky130_fd_pr__nfet_01v8 ad=0.169 pd=1.82 as=0.0878 ps=0.92 w=0.65 l=0.15
X657 VDPWR sky130_hd_ro41_nand_0.sky130_hd_inv_1_39.Y sky130_hd_ro41_nand_0.sky130_hd_inv_1_38.Y VDPWR sky130_fd_pr__pfet_01v8 ad=0.26 pd=2.52 as=0.135 ps=1.27 w=1 l=0.15
X658 uo_out[7] sky130_hd_ro41_nand_0.sky130_hd_inv_1_39.Y sky130_hd_ro41_nand_0.sky130_hd_inv_1_38.Y uo_out[7] sky130_fd_pr__nfet_01v8 ad=0.169 pd=1.82 as=0.0878 ps=0.92 w=0.65 l=0.15
X659 uo_out[7] sky130_hd_ro37_nand_0.sky130_hd_inv_1_12.Y sky130_hd_ro37_nand_0.sky130_hd_inv_1_11.Y uo_out[7] sky130_fd_pr__nfet_01v8 ad=0.169 pd=1.82 as=0.0878 ps=0.92 w=0.65 l=0.15
X660 VDPWR sky130_hd_xor_block_1.sky130_hd_xor2_1_0.A a_23018_31990# VDPWR sky130_fd_pr__pfet_01v8 ad=0.135 pd=1.27 as=0.135 ps=1.27 w=1 l=0.15
X661 VDPWR sky130_hd_ro47_nand_0.sky130_hd_inv_1_33.Y sky130_hd_ro47_nand_0.sky130_hd_inv_1_32.Y VDPWR sky130_fd_pr__pfet_01v8 ad=0.26 pd=2.52 as=0.135 ps=1.27 w=1 l=0.15
X662 uo_out[7] sky130_hd_ro53_nand_0.sky130_hd_inv_1_2.Y sky130_hd_ro53_nand_0.sky130_hd_inv_1_1.Y uo_out[7] sky130_fd_pr__nfet_01v8 ad=0.169 pd=1.82 as=0.0878 ps=0.92 w=0.65 l=0.15
X663 uo_out[7] sky130_hd_ro33_nand_0.sky130_hd_inv_1_19.Y sky130_hd_ro33_nand_0.sky130_hd_inv_1_18.Y uo_out[7] sky130_fd_pr__nfet_01v8 ad=0.169 pd=1.82 as=0.0878 ps=0.92 w=0.65 l=0.15
X664 sky130_hd_ro47_nand_0.sky130_hd_inv_1_23.Y sky130_hd_ro47_nand_0.sky130_hd_inv_1_24.Y VDPWR VDPWR sky130_fd_pr__pfet_01v8 ad=0.135 pd=1.27 as=0.26 ps=2.52 w=1 l=0.15
X665 sky130_hd_ro37_nand_0.sky130_hd_inv_1_2.A sky130_hd_ro37_nand_0.sky130_hd_inv_1_1.A uo_out[7] uo_out[7] sky130_fd_pr__nfet_01v8 ad=0.0878 pd=0.92 as=0.169 ps=1.82 w=0.65 l=0.15
X666 VDPWR sky130_hd_xor_block_1.sky130_hd_inv_1_1.Y sky130_hd_xor_block_1.sky130_hd_xor2_1_0.A VDPWR sky130_fd_pr__pfet_01v8 ad=0.26 pd=2.52 as=0.135 ps=1.27 w=1 l=0.15
X667 VDPWR sky130_hd_ro41_nand_0.sky130_hd_inv_1_24.Y sky130_hd_ro41_nand_0.sky130_hd_inv_1_23.Y VDPWR sky130_fd_pr__pfet_01v8 ad=0.26 pd=2.52 as=0.135 ps=1.27 w=1 l=0.15
X668 uo_out[7] sky130_hd_ro41_nand_0.sky130_hd_inv_1_24.Y sky130_hd_ro41_nand_0.sky130_hd_inv_1_23.Y uo_out[7] sky130_fd_pr__nfet_01v8 ad=0.169 pd=1.82 as=0.0878 ps=0.92 w=0.65 l=0.15
X669 VDPWR sky130_hd_ro53_nand_0.sky130_hd_inv_1_3.Y sky130_hd_ro53_nand_0.sky130_hd_inv_1_2.Y VDPWR sky130_fd_pr__pfet_01v8 ad=0.26 pd=2.52 as=0.135 ps=1.27 w=1 l=0.15
X670 sky130_hd_ro41_nand_0.sky130_hd_inv_1_17.Y sky130_hd_ro41_nand_0.sky130_hd_inv_1_18.Y VDPWR VDPWR sky130_fd_pr__pfet_01v8 ad=0.135 pd=1.27 as=0.26 ps=2.52 w=1 l=0.15
X671 sky130_hd_ro47_nand_0.sky130_hd_inv_1_5.Y sky130_hd_ro47_nand_0.sky130_hd_inv_1_16.Y uo_out[7] uo_out[7] sky130_fd_pr__nfet_01v8 ad=0.0878 pd=0.92 as=0.169 ps=1.82 w=0.65 l=0.15
X672 uo_out[7] sky130_hd_ro32_nand_0.sky130_hd_inv_1_23.Y sky130_hd_ro32_nand_0.sky130_hd_inv_1_22.Y uo_out[7] sky130_fd_pr__nfet_01v8 ad=0.169 pd=1.82 as=0.0878 ps=0.92 w=0.65 l=0.15
X673 VDPWR sky130_hd_ro32_nand_0.sky130_hd_nand2_1_0.Y sky130_hd_ro32_nand_0.sky130_hd_inv_1_31.Y VDPWR sky130_fd_pr__pfet_01v8 ad=0.26 pd=2.52 as=0.135 ps=1.27 w=1 l=0.15
X674 uo_out[7] sky130_hd_ro53_nand_0.sky130_hd_inv_1_6.Y sky130_hd_ro53_nand_0.sky130_hd_inv_1_5.Y uo_out[7] sky130_fd_pr__nfet_01v8 ad=0.169 pd=1.82 as=0.0878 ps=0.92 w=0.65 l=0.15
X675 uo_out[7] sky130_hd_ro33_nand_0.sky130_hd_inv_1_7.Y sky130_hd_ro33_nand_0.sky130_hd_inv_1_6.Y uo_out[7] sky130_fd_pr__nfet_01v8 ad=0.169 pd=1.82 as=0.0878 ps=0.92 w=0.65 l=0.15
X676 sky130_hd_ro41_nand_0.sky130_hd_inv_1_17.Y sky130_hd_ro41_nand_0.sky130_hd_inv_1_18.Y uo_out[7] uo_out[7] sky130_fd_pr__nfet_01v8 ad=0.0878 pd=0.92 as=0.169 ps=1.82 w=0.65 l=0.15
X677 uo_out[7] a_27536_1321# sky130_hd_div_by_2_1.Qb uo_out[7] sky130_fd_pr__nfet_01v8 ad=0.097 pd=0.975 as=0.169 ps=1.82 w=0.65 l=0.15
X678 VDPWR sky130_hd_ro32_nand_0.sky130_hd_inv_1_30.Y sky130_hd_ro32_nand_0.sky130_hd_inv_1_29.Y VDPWR sky130_fd_pr__pfet_01v8 ad=0.26 pd=2.52 as=0.135 ps=1.27 w=1 l=0.15
X679 sky130_hd_ro53_nand_0.sky130_hd_inv_1_42.Y sky130_hd_ro53_nand_0.sky130_hd_inv_1_43.Y uo_out[7] uo_out[7] sky130_fd_pr__nfet_01v8 ad=0.0878 pd=0.92 as=0.169 ps=1.82 w=0.65 l=0.15
X680 VDPWR sky130_hd_ro53_nand_0.sky130_hd_inv_1_18.A sky130_hd_ro53_nand_0.sky130_hd_inv_1_19.A VDPWR sky130_fd_pr__pfet_01v8 ad=0.26 pd=2.52 as=0.135 ps=1.27 w=1 l=0.15
X681 VDPWR sky130_hd_ro37_nand_0.sky130_hd_inv_1_16.Y sky130_hd_ro37_nand_0.sky130_hd_inv_1_15.Y VDPWR sky130_fd_pr__pfet_01v8 ad=0.26 pd=2.52 as=0.135 ps=1.27 w=1 l=0.15
X682 sky130_hd_ro41_nand_0.sky130_hd_inv_1_21.Y sky130_hd_ro41_nand_0.sky130_hd_inv_1_22.Y VDPWR VDPWR sky130_fd_pr__pfet_01v8 ad=0.135 pd=1.27 as=0.26 ps=2.52 w=1 l=0.15
X683 sky130_hd_ro41_nand_0.sky130_hd_inv_1_21.Y sky130_hd_ro41_nand_0.sky130_hd_inv_1_22.Y uo_out[7] uo_out[7] sky130_fd_pr__nfet_01v8 ad=0.0878 pd=0.92 as=0.169 ps=1.82 w=0.65 l=0.15
X684 sky130_hd_xor_block_2.sky130_hd_xor2_1_0.A sky130_hd_xor_block_2.sky130_hd_inv_1_1.Y uo_out[7] uo_out[7] sky130_fd_pr__nfet_01v8 ad=0.0878 pd=0.92 as=0.169 ps=1.82 w=0.65 l=0.15
X685 sky130_hd_ro53_nand_0.sky130_hd_nand2_1_0.Y ui_in[7] VDPWR VDPWR sky130_fd_pr__pfet_01v8 ad=0.135 pd=1.27 as=0.26 ps=2.52 w=1 l=0.15
X686 uo_out[7] a_28424_3247# a_28382_2979# uo_out[7] sky130_fd_pr__nfet_01v8 ad=0.109 pd=1.36 as=0.066 ps=0.745 w=0.42 l=0.15
X687 sky130_hd_ro37_nand_0.sky130_hd_inv_1_24.Y sky130_hd_ro37_nand_0.sky130_hd_inv_1_25.Y uo_out[7] uo_out[7] sky130_fd_pr__nfet_01v8 ad=0.0878 pd=0.92 as=0.169 ps=1.82 w=0.65 l=0.15
X688 VDPWR sky130_hd_ro47_nand_0.sky130_hd_inv_1_41.Y sky130_hd_ro47_nand_0.sky130_hd_inv_1_40.Y VDPWR sky130_fd_pr__pfet_01v8 ad=0.26 pd=2.52 as=0.135 ps=1.27 w=1 l=0.15
X689 VDPWR sky130_hd_ro32_nand_0.sky130_hd_inv_1_27.Y sky130_hd_ro32_nand_0.sky130_hd_inv_1_26.Y VDPWR sky130_fd_pr__pfet_01v8 ad=0.26 pd=2.52 as=0.135 ps=1.27 w=1 l=0.15
X690 VDPWR sky130_hd_ro53_nand_0.sky130_hd_inv_1_14.A sky130_hd_ro53_nand_0.sky130_hd_inv_1_15.A VDPWR sky130_fd_pr__pfet_01v8 ad=0.26 pd=2.52 as=0.135 ps=1.27 w=1 l=0.15
X691 sky130_hd_ro32_nand_0.sky130_hd_inv_1_31.Y sky130_hd_ro32_nand_0.sky130_hd_nand2_1_0.Y uo_out[7] uo_out[7] sky130_fd_pr__nfet_01v8 ad=0.0878 pd=0.92 as=0.169 ps=1.82 w=0.65 l=0.15
X692 uo_out[7] sky130_hd_ro33_nand_0.sky130_hd_nand2_1_0.Y sky130_hd_ro33_nand_0.sky130_hd_inv_1_31.Y uo_out[7] sky130_fd_pr__nfet_01v8 ad=0.169 pd=1.82 as=0.0878 ps=0.92 w=0.65 l=0.15
X693 VDPWR sky130_hd_ro37_nand_0.sky130_hd_inv_1_20.Y sky130_hd_ro37_nand_0.sky130_hd_inv_1_19.Y VDPWR sky130_fd_pr__pfet_01v8 ad=0.26 pd=2.52 as=0.135 ps=1.27 w=1 l=0.15
X694 sky130_hd_ro32_nand_0.sky130_hd_inv_1_29.Y sky130_hd_ro32_nand_0.sky130_hd_inv_1_30.Y uo_out[7] uo_out[7] sky130_fd_pr__nfet_01v8 ad=0.0878 pd=0.92 as=0.169 ps=1.82 w=0.65 l=0.15
X695 sky130_hd_ro47_nand_0.sky130_hd_inv_1_24.Y sky130_hd_ro47_nand_0.sky130_hd_inv_1_25.Y uo_out[7] uo_out[7] sky130_fd_pr__nfet_01v8 ad=0.0878 pd=0.92 as=0.169 ps=1.82 w=0.65 l=0.15
X696 uo_out[7] sky130_hd_ro53_nand_0.sky130_hd_inv_1_25.Y sky130_hd_ro53_nand_0.sky130_hd_inv_1_24.Y uo_out[7] sky130_fd_pr__nfet_01v8 ad=0.169 pd=1.82 as=0.0878 ps=0.92 w=0.65 l=0.15
X697 VDPWR sky130_hd_xor_block_3.XORA sky130_hd_xor_block_3.sky130_hd_inv_1_3.A VDPWR sky130_fd_pr__pfet_01v8 ad=0.26 pd=2.52 as=0.135 ps=1.27 w=1 l=0.15
X698 uo_out[7] sky130_hd_ro37_nand_0.sky130_hd_inv_1_9.Y sky130_hd_ro37_nand_0.sky130_hd_inv_1_8.Y uo_out[7] sky130_fd_pr__nfet_01v8 ad=0.169 pd=1.82 as=0.0878 ps=0.92 w=0.65 l=0.15
X699 sky130_hd_ro41_nand_0.sky130_hd_inv_1_26.Y sky130_hd_ro41_nand_0.sky130_hd_inv_1_27.Y VDPWR VDPWR sky130_fd_pr__pfet_01v8 ad=0.135 pd=1.27 as=0.26 ps=2.52 w=1 l=0.15
X700 sky130_hd_ro41_nand_0.sky130_hd_inv_1_26.Y sky130_hd_ro41_nand_0.sky130_hd_inv_1_27.Y uo_out[7] uo_out[7] sky130_fd_pr__nfet_01v8 ad=0.0878 pd=0.92 as=0.169 ps=1.82 w=0.65 l=0.15
X701 sky130_hd_ro47_nand_0.sky130_hd_inv_1_9.A sky130_hd_ro47_nand_0.sky130_hd_inv_1_8.A uo_out[7] uo_out[7] sky130_fd_pr__nfet_01v8 ad=0.0878 pd=0.92 as=0.169 ps=1.82 w=0.65 l=0.15
X702 VDPWR sky130_hd_ro53_nand_0.sky130_hd_inv_1_26.Y sky130_hd_ro53_nand_0.sky130_hd_inv_1_25.Y VDPWR sky130_fd_pr__pfet_01v8 ad=0.26 pd=2.52 as=0.135 ps=1.27 w=1 l=0.15
X703 sky130_hd_ro47_nand_0.sky130_hd_inv_1_2.Y sky130_hd_ro47_nand_0.sky130_hd_inv_1_3.Y VDPWR VDPWR sky130_fd_pr__pfet_01v8 ad=0.135 pd=1.27 as=0.26 ps=2.52 w=1 l=0.15
X704 sky130_hd_ro47_nand_0.sky130_hd_inv_1_28.Y sky130_hd_ro47_nand_0.sky130_hd_inv_1_29.Y uo_out[7] uo_out[7] sky130_fd_pr__nfet_01v8 ad=0.0878 pd=0.92 as=0.169 ps=1.82 w=0.65 l=0.15
X705 uo_out[7] a_28424_2159# a_28382_1891# uo_out[7] sky130_fd_pr__nfet_01v8 ad=0.109 pd=1.36 as=0.066 ps=0.745 w=0.42 l=0.15
X706 a_21678_35715# a_21774_35537# uo_out[7] uo_out[7] sky130_fd_pr__nfet_01v8 ad=0.169 pd=1.82 as=0.0878 ps=0.92 w=0.65 l=0.15
X707 VDPWR sky130_hd_ro33_nand_0.sky130_hd_inv_1_11.Y sky130_hd_ro33_nand_0.sky130_hd_inv_1_10.Y VDPWR sky130_fd_pr__pfet_01v8 ad=0.26 pd=2.52 as=0.135 ps=1.27 w=1 l=0.15
X708 sky130_hd_ro33_nand_0.sky130_hd_inv_1_9.Y sky130_hd_ro33_nand_0.sky130_hd_inv_1_10.Y uo_out[7] uo_out[7] sky130_fd_pr__nfet_01v8 ad=0.0878 pd=0.92 as=0.169 ps=1.82 w=0.65 l=0.15
X709 sky130_hd_xor_block_3.XORA sky130_hd_ro33_nand_0.sky130_hd_inv_1_1.Y VDPWR VDPWR sky130_fd_pr__pfet_01v8 ad=0.135 pd=1.27 as=0.26 ps=2.52 w=1 l=0.15
X710 sky130_hd_ro41_nand_0.sky130_hd_inv_1_14.Y sky130_hd_ro41_nand_0.sky130_hd_inv_1_15.Y VDPWR VDPWR sky130_fd_pr__pfet_01v8 ad=0.135 pd=1.27 as=0.26 ps=2.52 w=1 l=0.15
X711 sky130_hd_ro41_nand_0.sky130_hd_inv_1_14.Y sky130_hd_ro41_nand_0.sky130_hd_inv_1_15.Y uo_out[7] uo_out[7] sky130_fd_pr__nfet_01v8 ad=0.0878 pd=0.92 as=0.169 ps=1.82 w=0.65 l=0.15
X712 sky130_hd_ro53_nand_0.sky130_hd_inv_1_36.Y sky130_hd_ro53_nand_0.sky130_hd_inv_1_37.Y VDPWR VDPWR sky130_fd_pr__pfet_01v8 ad=0.135 pd=1.27 as=0.26 ps=2.52 w=1 l=0.15
X713 sky130_hd_ro53_nand_0.sky130_hd_inv_1_16.A sky130_hd_ro53_nand_0.sky130_hd_inv_1_15.A VDPWR VDPWR sky130_fd_pr__pfet_01v8 ad=0.135 pd=1.27 as=0.26 ps=2.52 w=1 l=0.15
X714 VDPWR sky130_hd_inv_1_0.A sky130_hd_inv_4_0.A VDPWR sky130_fd_pr__pfet_01v8 ad=0.26 pd=2.52 as=0.135 ps=1.27 w=1 l=0.15
X715 VDPWR sky130_hd_ro47_nand_0.sky130_hd_inv_1_35.Y sky130_hd_ro47_nand_0.sky130_hd_inv_1_34.Y VDPWR sky130_fd_pr__pfet_01v8 ad=0.26 pd=2.52 as=0.135 ps=1.27 w=1 l=0.15
X716 VDPWR sky130_hd_ro37_nand_0.sky130_hd_inv_1_13.Y sky130_hd_ro37_nand_0.sky130_hd_inv_1_12.Y VDPWR sky130_fd_pr__pfet_01v8 ad=0.26 pd=2.52 as=0.135 ps=1.27 w=1 l=0.15
X717 sky130_hd_ro47_nand_0.sky130_hd_inv_1_16.A sky130_hd_ro47_nand_0.sky130_hd_inv_1_15.A VDPWR VDPWR sky130_fd_pr__pfet_01v8 ad=0.135 pd=1.27 as=0.26 ps=2.52 w=1 l=0.15
X718 uo_out[7] a_28188_3741# a_28195_3645# uo_out[7] sky130_fd_pr__nfet_01v8 ad=0.0567 pd=0.69 as=0.109 ps=1.36 w=0.42 l=0.15
X719 sky130_hd_ro32_nand_0.sky130_hd_inv_1_1.Y sky130_hd_ro32_nand_0.sky130_hd_inv_1_2.Y VDPWR VDPWR sky130_fd_pr__pfet_01v8 ad=0.135 pd=1.27 as=0.26 ps=2.52 w=1 l=0.15
X720 VDPWR sky130_hd_inv_4_0.A uo_out[0] VDPWR sky130_fd_pr__pfet_01v8_hvt ad=0.135 pd=1.27 as=0.135 ps=1.27 w=1 l=0.15
X721 uo_out[7] sky130_hd_ro47_nand_0.sky130_hd_inv_1_34.Y sky130_hd_ro47_nand_0.sky130_hd_inv_1_33.Y uo_out[7] sky130_fd_pr__nfet_01v8 ad=0.169 pd=1.82 as=0.0878 ps=0.92 w=0.65 l=0.15
X722 VDPWR a_23743_35715# sky130_hd_dfxtp_1_1.Q VDPWR sky130_fd_pr__pfet_01v8_hvt ad=0.135 pd=1.27 as=0.26 ps=2.52 w=1 l=0.15
X723 sky130_hd_ro41_nand_0.sky130_hd_inv_1_19.Y sky130_hd_ro41_nand_0.sky130_hd_inv_1_20.Y VDPWR VDPWR sky130_fd_pr__pfet_01v8 ad=0.135 pd=1.27 as=0.26 ps=2.52 w=1 l=0.15
X724 VDPWR sky130_hd_ro47_nand_0.sky130_hd_inv_1_38.Y sky130_hd_ro47_nand_0.sky130_hd_inv_1_37.Y VDPWR sky130_fd_pr__pfet_01v8 ad=0.26 pd=2.52 as=0.135 ps=1.27 w=1 l=0.15
X725 VDPWR ua[0] sky130_hd_ro32_nand_0.sky130_hd_nand2_1_0.Y VDPWR sky130_fd_pr__pfet_01v8 ad=0.26 pd=2.52 as=0.135 ps=1.27 w=1 l=0.15
X726 sky130_hd_ro33_nand_0.sky130_hd_inv_1_27.Y sky130_hd_ro33_nand_0.sky130_hd_inv_1_28.Y uo_out[7] uo_out[7] sky130_fd_pr__nfet_01v8 ad=0.0878 pd=0.92 as=0.169 ps=1.82 w=0.65 l=0.15
X727 sky130_hd_ro41_nand_0.sky130_hd_inv_1_38.Y sky130_hd_ro41_nand_0.sky130_hd_inv_1_39.Y VDPWR VDPWR sky130_fd_pr__pfet_01v8 ad=0.135 pd=1.27 as=0.26 ps=2.52 w=1 l=0.15
X728 sky130_hd_ro41_nand_0.sky130_hd_inv_1_38.Y sky130_hd_ro41_nand_0.sky130_hd_inv_1_39.Y uo_out[7] uo_out[7] sky130_fd_pr__nfet_01v8 ad=0.0878 pd=0.92 as=0.169 ps=1.82 w=0.65 l=0.15
X729 sky130_hd_ro41_nand_0.sky130_hd_inv_1_19.Y sky130_hd_ro41_nand_0.sky130_hd_inv_1_20.Y uo_out[7] uo_out[7] sky130_fd_pr__nfet_01v8 ad=0.0878 pd=0.92 as=0.169 ps=1.82 w=0.65 l=0.15
X730 VDPWR sky130_hd_ro33_nand_0.sky130_hd_inv_1_29.Y sky130_hd_ro33_nand_0.sky130_hd_inv_1_28.Y VDPWR sky130_fd_pr__pfet_01v8 ad=0.26 pd=2.52 as=0.135 ps=1.27 w=1 l=0.15
X731 sky130_hd_ro32_nand_0.sky130_hd_inv_1_5.Y sky130_hd_ro32_nand_0.sky130_hd_inv_1_6.Y VDPWR VDPWR sky130_fd_pr__pfet_01v8 ad=0.135 pd=1.27 as=0.26 ps=2.52 w=1 l=0.15
X732 sky130_hd_ro53_nand_0.sky130_hd_inv_1_1.Y sky130_hd_ro53_nand_0.sky130_hd_inv_1_2.Y uo_out[7] uo_out[7] sky130_fd_pr__nfet_01v8 ad=0.0878 pd=0.92 as=0.169 ps=1.82 w=0.65 l=0.15
X733 VDPWR sky130_hd_ro41_nand_0.sky130_hd_inv_1_32.Y sky130_hd_ro41_nand_0.sky130_hd_inv_1_31.Y VDPWR sky130_fd_pr__pfet_01v8 ad=0.26 pd=2.52 as=0.135 ps=1.27 w=1 l=0.15
X734 a_23839_35537# a_24123_35537# a_24058_35563# uo_out[7] sky130_fd_pr__special_nfet_01v8 ad=0.0684 pd=0.74 as=0.066 ps=0.745 w=0.36 l=0.15
X735 sky130_hd_xor_block_1.XOROUT a_22936_31990# a_23186_31990# VDPWR sky130_fd_pr__pfet_01v8 ad=0.3 pd=2.6 as=0.26 ps=2.52 w=1 l=0.15
X736 sky130_hd_ro41_nand_0.sky130_hd_inv_1_23.Y sky130_hd_ro41_nand_0.sky130_hd_inv_1_24.Y VDPWR VDPWR sky130_fd_pr__pfet_01v8 ad=0.135 pd=1.27 as=0.26 ps=2.52 w=1 l=0.15
X737 uo_out[7] sky130_hd_ro41_nand_0.sky130_hd_inv_1_32.Y sky130_hd_ro41_nand_0.sky130_hd_inv_1_31.Y uo_out[7] sky130_fd_pr__nfet_01v8 ad=0.169 pd=1.82 as=0.0878 ps=0.92 w=0.65 l=0.15
X738 VDPWR sky130_hd_xor_block_2.sky130_hd_xor2_1_0.A a_21261_33268# VDPWR sky130_fd_pr__pfet_01v8 ad=0.135 pd=1.27 as=0.135 ps=1.27 w=1 l=0.15
X739 sky130_hd_ro41_nand_0.sky130_hd_inv_1_23.Y sky130_hd_ro41_nand_0.sky130_hd_inv_1_24.Y uo_out[7] uo_out[7] sky130_fd_pr__nfet_01v8 ad=0.0878 pd=0.92 as=0.169 ps=1.82 w=0.65 l=0.15
X740 sky130_hd_ro47_nand_0.sky130_hd_nand2_1_0.Y sky130_hd_xor_block_1.XORB a_4631_27642# uo_out[7] sky130_fd_pr__nfet_01v8 ad=0.169 pd=1.82 as=0.0878 ps=0.92 w=0.65 l=0.15
X741 sky130_hd_ro53_nand_0.sky130_hd_inv_1_29.Y sky130_hd_ro53_nand_0.sky130_hd_inv_1_30.Y VDPWR VDPWR sky130_fd_pr__pfet_01v8 ad=0.135 pd=1.27 as=0.26 ps=2.52 w=1 l=0.15
X742 uo_out[7] sky130_hd_ro37_nand_0.sky130_hd_inv_1_35.Y sky130_hd_ro37_nand_0.sky130_hd_inv_1_34.Y uo_out[7] sky130_fd_pr__nfet_01v8 ad=0.169 pd=1.82 as=0.0878 ps=0.92 w=0.65 l=0.15
X743 uo_out[7] sky130_hd_ro53_nand_0.sky130_hd_inv_1_42.Y sky130_hd_ro53_nand_0.sky130_hd_inv_1_41.A uo_out[7] sky130_fd_pr__nfet_01v8 ad=0.169 pd=1.82 as=0.0878 ps=0.92 w=0.65 l=0.15
X744 sky130_hd_ro33_nand_0.sky130_hd_inv_1_6.Y sky130_hd_ro33_nand_0.sky130_hd_inv_1_7.Y uo_out[7] uo_out[7] sky130_fd_pr__nfet_01v8 ad=0.0878 pd=0.92 as=0.169 ps=1.82 w=0.65 l=0.15
X745 sky130_hd_ro37_nand_0.sky130_hd_inv_1_25.A sky130_hd_ro37_nand_0.sky130_hd_inv_1_26.Y uo_out[7] uo_out[7] sky130_fd_pr__nfet_01v8 ad=0.0878 pd=0.92 as=0.169 ps=1.82 w=0.65 l=0.15
X746 VDPWR sky130_hd_ro47_nand_0.sky130_hd_inv_1_43.Y sky130_hd_ro47_nand_0.sky130_hd_inv_1_42.Y VDPWR sky130_fd_pr__pfet_01v8 ad=0.26 pd=2.52 as=0.135 ps=1.27 w=1 l=0.15
X747 sky130_hd_ro53_nand_0.sky130_hd_inv_1_20.A sky130_hd_ro53_nand_0.sky130_hd_inv_1_19.A uo_out[7] uo_out[7] sky130_fd_pr__nfet_01v8 ad=0.0878 pd=0.92 as=0.169 ps=1.82 w=0.65 l=0.15
X748 VDPWR sky130_hd_ro37_nand_0.sky130_hd_inv_1_22.Y sky130_hd_ro37_nand_0.sky130_hd_inv_1_21.Y VDPWR sky130_fd_pr__pfet_01v8 ad=0.26 pd=2.52 as=0.135 ps=1.27 w=1 l=0.15
X749 sky130_hd_ro47_nand_0.sky130_hd_inv_1_45.Y sky130_hd_ro47_nand_0.sky130_hd_nand2_1_0.Y uo_out[7] uo_out[7] sky130_fd_pr__nfet_01v8 ad=0.0878 pd=0.92 as=0.169 ps=1.82 w=0.65 l=0.15
X750 sky130_hd_ro53_nand_0.sky130_hd_inv_1_33.Y sky130_hd_ro53_nand_0.sky130_hd_inv_1_34.Y VDPWR VDPWR sky130_fd_pr__pfet_01v8 ad=0.135 pd=1.27 as=0.26 ps=2.52 w=1 l=0.15
X751 sky130_hd_ro53_nand_0.sky130_hd_inv_1_19.A sky130_hd_ro53_nand_0.sky130_hd_inv_1_18.A VDPWR VDPWR sky130_fd_pr__pfet_01v8 ad=0.135 pd=1.27 as=0.26 ps=2.52 w=1 l=0.15
X752 a_28742_1725# a_28195_1469# a_28395_1624# VDPWR sky130_fd_pr__pfet_01v8_hvt ad=0.0578 pd=0.695 as=0.0683 ps=0.745 w=0.42 l=0.15
X753 uo_out[7] sky130_hd_ro53_nand_0.sky130_hd_inv_1_27.Y sky130_hd_ro53_nand_0.sky130_hd_inv_1_26.Y uo_out[7] sky130_fd_pr__nfet_01v8 ad=0.169 pd=1.82 as=0.0878 ps=0.92 w=0.65 l=0.15
X754 VDPWR sky130_hd_xor_block_0.sky130_hd_xor2_1_0.B a_25118_30833# VDPWR sky130_fd_pr__pfet_01v8 ad=0.26 pd=2.52 as=0.135 ps=1.27 w=1 l=0.15
X755 VDPWR sky130_hd_ro41_nand_0.sky130_hd_inv_1_37.Y sky130_hd_ro41_nand_0.sky130_hd_inv_1_36.Y VDPWR sky130_fd_pr__pfet_01v8 ad=0.26 pd=2.52 as=0.135 ps=1.27 w=1 l=0.15
X756 sky130_hd_ro32_nand_0.sky130_hd_inv_1_18.Y sky130_hd_ro32_nand_0.sky130_hd_inv_1_19.Y uo_out[7] uo_out[7] sky130_fd_pr__nfet_01v8 ad=0.0878 pd=0.92 as=0.169 ps=1.82 w=0.65 l=0.15
X757 uo_out[7] sky130_hd_ro53_nand_0.sky130_hd_inv_1_46.Y sky130_hd_ro53_nand_0.sky130_hd_inv_1_45.Y uo_out[7] sky130_fd_pr__nfet_01v8 ad=0.169 pd=1.82 as=0.0878 ps=0.92 w=0.65 l=0.15
X758 uo_out[7] sky130_hd_ro41_nand_0.sky130_hd_inv_1_37.Y sky130_hd_ro41_nand_0.sky130_hd_inv_1_36.Y uo_out[7] sky130_fd_pr__nfet_01v8 ad=0.169 pd=1.82 as=0.0878 ps=0.92 w=0.65 l=0.15
X759 VDPWR sky130_hd_ro47_nand_0.sky130_hd_inv_1_32.Y sky130_hd_ro47_nand_0.sky130_hd_inv_1_31.Y VDPWR sky130_fd_pr__pfet_01v8 ad=0.26 pd=2.52 as=0.135 ps=1.27 w=1 l=0.15
X760 sky130_hd_ro33_nand_0.sky130_hd_inv_1_20.Y sky130_hd_ro33_nand_0.sky130_hd_inv_1_21.Y uo_out[7] uo_out[7] sky130_fd_pr__nfet_01v8 ad=0.0878 pd=0.92 as=0.169 ps=1.82 w=0.65 l=0.15
X761 VDPWR sky130_hd_ro37_nand_0.sky130_hd_inv_1_10.Y sky130_hd_ro37_nand_0.sky130_hd_inv_1_9.Y VDPWR sky130_fd_pr__pfet_01v8 ad=0.26 pd=2.52 as=0.135 ps=1.27 w=1 l=0.15
X762 VDPWR sky130_hd_ro53_nand_0.sky130_hd_inv_1_28.Y sky130_hd_ro53_nand_0.sky130_hd_inv_1_27.Y VDPWR sky130_fd_pr__pfet_01v8 ad=0.26 pd=2.52 as=0.135 ps=1.27 w=1 l=0.15
X763 VDPWR sky130_hd_ro32_nand_0.sky130_hd_inv_1_13.Y sky130_hd_ro32_nand_0.sky130_hd_inv_1_12.Y VDPWR sky130_fd_pr__pfet_01v8 ad=0.26 pd=2.52 as=0.135 ps=1.27 w=1 l=0.15
X764 sky130_hd_xor_block_3.sky130_hd_xor2_1_0.B sky130_hd_xor_block_3.sky130_hd_inv_1_3.A uo_out[7] uo_out[7] sky130_fd_pr__nfet_01v8 ad=0.0878 pd=0.92 as=0.169 ps=1.82 w=0.65 l=0.15
X765 uo_out[7] sky130_hd_ro47_nand_0.sky130_hd_inv_1_31.Y sky130_hd_ro47_nand_0.sky130_hd_inv_1_30.Y uo_out[7] sky130_fd_pr__nfet_01v8 ad=0.169 pd=1.82 as=0.0878 ps=0.92 w=0.65 l=0.15
X766 sky130_hd_ro32_nand_0.sky130_hd_inv_1_15.Y sky130_hd_ro32_nand_0.sky130_hd_inv_1_16.Y uo_out[7] uo_out[7] sky130_fd_pr__nfet_01v8 ad=0.0878 pd=0.92 as=0.169 ps=1.82 w=0.65 l=0.15
X767 uo_out[7] sky130_hd_ro47_nand_0.sky130_hd_inv_1_9.A sky130_hd_ro47_nand_0.sky130_hd_inv_1_10.A uo_out[7] sky130_fd_pr__nfet_01v8 ad=0.169 pd=1.82 as=0.0878 ps=0.92 w=0.65 l=0.15
X768 VDPWR sky130_hd_inv_4_0.A uo_out[0] VDPWR sky130_fd_pr__pfet_01v8_hvt ad=0.26 pd=2.52 as=0.135 ps=1.27 w=1 l=0.15
X769 sky130_hd_ro33_nand_0.sky130_hd_inv_1_24.Y sky130_hd_ro33_nand_0.sky130_hd_inv_1_25.Y uo_out[7] uo_out[7] sky130_fd_pr__nfet_01v8 ad=0.0878 pd=0.92 as=0.169 ps=1.82 w=0.65 l=0.15
X770 sky130_hd_ro32_nand_0.sky130_hd_inv_1_22.Y sky130_hd_ro32_nand_0.sky130_hd_inv_1_23.Y VDPWR VDPWR sky130_fd_pr__pfet_01v8 ad=0.135 pd=1.27 as=0.26 ps=2.52 w=1 l=0.15
X771 uo_out[7] sky130_hd_ro53_nand_0.sky130_hd_inv_1_51.Y sky130_hd_ro53_nand_0.sky130_hd_inv_1_50.Y uo_out[7] sky130_fd_pr__nfet_01v8 ad=0.169 pd=1.82 as=0.0878 ps=0.92 w=0.65 l=0.15
X772 uo_out[7] sky130_hd_ro33_nand_0.sky130_hd_inv_1_5.Y sky130_hd_ro33_nand_0.sky130_hd_inv_1_4.Y uo_out[7] sky130_fd_pr__nfet_01v8 ad=0.169 pd=1.82 as=0.0878 ps=0.92 w=0.65 l=0.15
X773 sky130_hd_ro37_nand_0.sky130_hd_inv_1_4.A sky130_hd_ro37_nand_0.sky130_hd_inv_1_3.A VDPWR VDPWR sky130_fd_pr__pfet_01v8 ad=0.135 pd=1.27 as=0.26 ps=2.52 w=1 l=0.15
X774 VDPWR sky130_hd_ro37_nand_0.sky130_hd_inv_1_34.Y sky130_hd_ro37_nand_0.sky130_hd_inv_1_33.Y VDPWR sky130_fd_pr__pfet_01v8 ad=0.26 pd=2.52 as=0.135 ps=1.27 w=1 l=0.15
X775 VDPWR sky130_hd_ro37_nand_0.sky130_hd_inv_1_15.Y sky130_hd_ro37_nand_0.sky130_hd_inv_1_14.Y VDPWR sky130_fd_pr__pfet_01v8 ad=0.26 pd=2.52 as=0.135 ps=1.27 w=1 l=0.15
X776 uo_out[7] sky130_hd_ro47_nand_0.sky130_hd_inv_1_44.Y sky130_hd_ro47_nand_0.sky130_hd_inv_1_43.Y uo_out[7] sky130_fd_pr__nfet_01v8 ad=0.169 pd=1.82 as=0.0878 ps=0.92 w=0.65 l=0.15
X777 uo_out[7] sky130_hd_ro32_nand_0.sky130_hd_inv_1_10.Y sky130_hd_ro32_nand_0.sky130_hd_inv_1_9.Y uo_out[7] sky130_fd_pr__nfet_01v8 ad=0.169 pd=1.82 as=0.0878 ps=0.92 w=0.65 l=0.15
X778 sky130_hd_ro32_nand_0.sky130_hd_inv_1_19.Y sky130_hd_ro32_nand_0.sky130_hd_inv_1_20.Y VDPWR VDPWR sky130_fd_pr__pfet_01v8 ad=0.135 pd=1.27 as=0.26 ps=2.52 w=1 l=0.15
X779 uo_out[7] sky130_hd_ro53_nand_0.sky130_hd_inv_1_40.Y sky130_hd_ro53_nand_0.sky130_hd_inv_1_39.Y uo_out[7] sky130_fd_pr__nfet_01v8 ad=0.169 pd=1.82 as=0.0878 ps=0.92 w=0.65 l=0.15
X780 VDPWR sky130_hd_ro32_nand_0.sky130_hd_inv_1_17.Y sky130_hd_ro32_nand_0.sky130_hd_inv_1_16.Y VDPWR sky130_fd_pr__pfet_01v8 ad=0.26 pd=2.52 as=0.135 ps=1.27 w=1 l=0.15
X781 sky130_hd_ro53_nand_0.sky130_hd_inv_1_22.Y sky130_hd_ro53_nand_0.sky130_hd_inv_1_22.A uo_out[7] uo_out[7] sky130_fd_pr__nfet_01v8 ad=0.0878 pd=0.92 as=0.169 ps=1.82 w=0.65 l=0.15
X782 VDPWR sky130_hd_ro33_nand_0.sky130_hd_inv_1_4.Y sky130_hd_ro33_nand_0.sky130_hd_inv_1_3.Y VDPWR sky130_fd_pr__pfet_01v8 ad=0.26 pd=2.52 as=0.135 ps=1.27 w=1 l=0.15
X783 VDPWR sky130_hd_ro37_nand_0.sky130_hd_inv_1_19.Y sky130_hd_ro37_nand_0.sky130_hd_inv_1_18.Y VDPWR sky130_fd_pr__pfet_01v8 ad=0.26 pd=2.52 as=0.135 ps=1.27 w=1 l=0.15
X784 sky130_hd_ro47_nand_0.sky130_hd_inv_1_34.Y sky130_hd_ro47_nand_0.sky130_hd_inv_1_35.Y VDPWR VDPWR sky130_fd_pr__pfet_01v8 ad=0.135 pd=1.27 as=0.26 ps=2.52 w=1 l=0.15
X785 uo_out[7] sky130_hd_ro33_nand_0.sky130_hd_inv_1_30.Y sky130_hd_ro33_nand_0.sky130_hd_inv_1_29.Y uo_out[7] sky130_fd_pr__nfet_01v8 ad=0.169 pd=1.82 as=0.0878 ps=0.92 w=0.65 l=0.15
X786 sky130_hd_ro47_nand_0.sky130_hd_inv_1_27.Y sky130_hd_ro47_nand_0.sky130_hd_inv_1_28.Y VDPWR VDPWR sky130_fd_pr__pfet_01v8 ad=0.135 pd=1.27 as=0.26 ps=2.52 w=1 l=0.15
X787 sky130_hd_ro53_nand_0.sky130_hd_inv_1_22.A sky130_hd_ro53_nand_0.sky130_hd_inv_1_21.A VDPWR VDPWR sky130_fd_pr__pfet_01v8 ad=0.135 pd=1.27 as=0.26 ps=2.52 w=1 l=0.15
X788 uo_out[7] sky130_hd_ro53_nand_0.sky130_hd_inv_1_24.Y sky130_hd_ro53_nand_0.sky130_hd_inv_1_13.A uo_out[7] sky130_fd_pr__nfet_01v8 ad=0.169 pd=1.82 as=0.0878 ps=0.92 w=0.65 l=0.15
X789 sky130_hd_ro37_nand_0.sky130_hd_inv_1_12.Y sky130_hd_ro37_nand_0.sky130_hd_inv_1_13.Y VDPWR VDPWR sky130_fd_pr__pfet_01v8 ad=0.135 pd=1.27 as=0.26 ps=2.52 w=1 l=0.15
X790 VDPWR sky130_hd_ro41_nand_0.sky130_hd_inv_1_34.Y sky130_hd_ro41_nand_0.sky130_hd_inv_1_33.Y VDPWR sky130_fd_pr__pfet_01v8 ad=0.26 pd=2.52 as=0.135 ps=1.27 w=1 l=0.15
X791 sky130_hd_ro37_nand_0.sky130_hd_inv_1_10.Y sky130_hd_ro37_nand_0.sky130_hd_inv_1_11.Y uo_out[7] uo_out[7] sky130_fd_pr__nfet_01v8 ad=0.0878 pd=0.92 as=0.169 ps=1.82 w=0.65 l=0.15
X792 uo_out[7] sky130_hd_ro41_nand_0.sky130_hd_inv_1_34.Y sky130_hd_ro41_nand_0.sky130_hd_inv_1_33.Y uo_out[7] sky130_fd_pr__nfet_01v8 ad=0.169 pd=1.82 as=0.0878 ps=0.92 w=0.65 l=0.15
X793 VDPWR sky130_hd_ro32_nand_0.sky130_hd_inv_1_14.Y sky130_hd_ro32_nand_0.sky130_hd_inv_1_13.Y VDPWR sky130_fd_pr__pfet_01v8 ad=0.26 pd=2.52 as=0.135 ps=1.27 w=1 l=0.15
X794 sky130_hd_ro47_nand_0.sky130_hd_inv_1_18.Y sky130_hd_ro47_nand_0.sky130_hd_inv_1_19.Y VDPWR VDPWR sky130_fd_pr__pfet_01v8 ad=0.135 pd=1.27 as=0.26 ps=2.52 w=1 l=0.15
X795 VDPWR sky130_hd_xor_block_0.XORB sky130_hd_ro53_nand_0.sky130_hd_nand2_1_0.Y VDPWR sky130_fd_pr__pfet_01v8 ad=0.26 pd=2.52 as=0.135 ps=1.27 w=1 l=0.15
X796 sky130_hd_ro32_nand_0.sky130_hd_inv_1_16.Y sky130_hd_ro32_nand_0.sky130_hd_inv_1_17.Y uo_out[7] uo_out[7] sky130_fd_pr__nfet_01v8 ad=0.0878 pd=0.92 as=0.169 ps=1.82 w=0.65 l=0.15
X797 VDPWR sky130_hd_ro33_nand_0.sky130_hd_inv_1_9.Y sky130_hd_ro33_nand_0.sky130_hd_inv_1_8.Y VDPWR sky130_fd_pr__pfet_01v8 ad=0.26 pd=2.52 as=0.135 ps=1.27 w=1 l=0.15
X798 sky130_hd_ro41_nand_0.sky130_hd_inv_1_12.Y sky130_hd_ro41_nand_0.sky130_hd_inv_1_13.Y VDPWR VDPWR sky130_fd_pr__pfet_01v8 ad=0.135 pd=1.27 as=0.26 ps=2.52 w=1 l=0.15
X799 uo_out[7] sky130_hd_ro47_nand_0.sky130_hd_inv_1_12.A sky130_hd_ro47_nand_0.sky130_hd_inv_1_13.A uo_out[7] sky130_fd_pr__nfet_01v8 ad=0.169 pd=1.82 as=0.0878 ps=0.92 w=0.65 l=0.15
X800 sky130_hd_xor_block_1.XORB sky130_hd_ro47_nand_0.sky130_hd_inv_1_1.Y uo_out[7] uo_out[7] sky130_fd_pr__nfet_01v8 ad=0.0878 pd=0.92 as=0.169 ps=1.82 w=0.65 l=0.15
X801 uo_out[7] sky130_hd_ro33_nand_0.sky130_hd_inv_1_2.Y sky130_hd_ro33_nand_0.sky130_hd_inv_1_1.Y uo_out[7] sky130_fd_pr__nfet_01v8 ad=0.169 pd=1.82 as=0.0878 ps=0.92 w=0.65 l=0.15
X802 VDPWR sky130_hd_xor_block_3.sky130_hd_xor2_1_0.B a_19695_33932# VDPWR sky130_fd_pr__pfet_01v8 ad=0.26 pd=2.52 as=0.135 ps=1.27 w=1 l=0.15
X803 sky130_hd_ro41_nand_0.sky130_hd_inv_1_12.Y sky130_hd_ro41_nand_0.sky130_hd_inv_1_13.Y uo_out[7] uo_out[7] sky130_fd_pr__nfet_01v8 ad=0.0878 pd=0.92 as=0.169 ps=1.82 w=0.65 l=0.15
X804 sky130_hd_ro53_nand_0.sky130_hd_inv_1_17.A sky130_hd_ro53_nand_0.sky130_hd_inv_1_16.A VDPWR VDPWR sky130_fd_pr__pfet_01v8 ad=0.135 pd=1.27 as=0.26 ps=2.52 w=1 l=0.15
X805 VDPWR a_28424_3247# a_28855_3301# VDPWR sky130_fd_pr__pfet_01v8_hvt ad=0.154 pd=1.34 as=0.166 ps=1.8 w=0.64 l=0.15
X806 a_27831_3345# a_27558_2979# a_27746_2979# VDPWR sky130_fd_pr__pfet_01v8_hvt ad=0.0683 pd=0.745 as=0.0578 ps=0.695 w=0.42 l=0.15
X807 uo_out[7] sky130_hd_ro53_nand_0.sky130_hd_inv_1_48.Y sky130_hd_ro53_nand_0.sky130_hd_inv_1_47.Y uo_out[7] sky130_fd_pr__nfet_01v8 ad=0.169 pd=1.82 as=0.0878 ps=0.92 w=0.65 l=0.15
X808 sky130_hd_ro37_nand_0.sky130_hd_inv_1_15.Y sky130_hd_ro37_nand_0.sky130_hd_inv_1_16.Y uo_out[7] uo_out[7] sky130_fd_pr__nfet_01v8 ad=0.0878 pd=0.92 as=0.169 ps=1.82 w=0.65 l=0.15
X809 sky130_hd_ro53_nand_0.sky130_hd_inv_1_14.A sky130_hd_ro53_nand_0.sky130_hd_inv_1_13.A uo_out[7] uo_out[7] sky130_fd_pr__nfet_01v8 ad=0.0878 pd=0.92 as=0.169 ps=1.82 w=0.65 l=0.15
X810 VDPWR sky130_hd_ro53_nand_0.sky130_hd_inv_1_22.Y sky130_hd_ro53_nand_0.sky130_hd_inv_1_11.Y VDPWR sky130_fd_pr__pfet_01v8 ad=0.26 pd=2.52 as=0.135 ps=1.27 w=1 l=0.15
X811 uo_out[7] a_27631_1674# ua[1] uo_out[7] sky130_fd_pr__nfet_01v8 ad=0.0878 pd=0.92 as=0.169 ps=1.82 w=0.65 l=0.15
X812 uo_out[7] a_28395_3800# a_28324_3901# uo_out[7] sky130_fd_pr__nfet_01v8 ad=0.121 pd=1.09 as=0.0989 ps=0.995 w=0.64 l=0.15
X813 a_28188_1565# sky130_hd_div_by_2_1.CLK uo_out[7] uo_out[7] sky130_fd_pr__nfet_01v8 ad=0.109 pd=1.36 as=0.0567 ps=0.69 w=0.42 l=0.15
X814 sky130_hd_ro37_nand_0.sky130_hd_inv_1_3.A sky130_hd_ro37_nand_0.sky130_hd_inv_1_2.A VDPWR VDPWR sky130_fd_pr__pfet_01v8 ad=0.135 pd=1.27 as=0.26 ps=2.52 w=1 l=0.15
X815 a_24123_35537# clk VDPWR VDPWR sky130_fd_pr__pfet_01v8_hvt ad=0.166 pd=1.8 as=0.0864 ps=0.91 w=0.64 l=0.15
X816 sky130_hd_ro37_nand_0.sky130_hd_inv_1_19.Y sky130_hd_ro37_nand_0.sky130_hd_inv_1_20.Y uo_out[7] uo_out[7] sky130_fd_pr__nfet_01v8 ad=0.0878 pd=0.92 as=0.169 ps=1.82 w=0.65 l=0.15
X817 sky130_hd_ro53_nand_0.sky130_hd_inv_1_26.Y sky130_hd_ro53_nand_0.sky130_hd_inv_1_27.Y uo_out[7] uo_out[7] sky130_fd_pr__nfet_01v8 ad=0.0878 pd=0.92 as=0.169 ps=1.82 w=0.65 l=0.15
X818 sky130_hd_ro33_nand_0.sky130_hd_inv_1_26.Y sky130_hd_ro33_nand_0.sky130_hd_inv_1_27.Y uo_out[7] uo_out[7] sky130_fd_pr__nfet_01v8 ad=0.0878 pd=0.92 as=0.169 ps=1.82 w=0.65 l=0.15
X819 a_25118_30833# sky130_hd_xor_block_0.sky130_hd_xor2_1_0.A VDPWR VDPWR sky130_fd_pr__pfet_01v8 ad=0.135 pd=1.27 as=0.135 ps=1.27 w=1 l=0.15
X820 sky130_hd_ro47_nand_0.sky130_hd_inv_1_31.Y sky130_hd_ro47_nand_0.sky130_hd_inv_1_32.Y VDPWR VDPWR sky130_fd_pr__pfet_01v8 ad=0.135 pd=1.27 as=0.26 ps=2.52 w=1 l=0.15
X821 uo_out[7] sky130_hd_ro32_nand_0.sky130_hd_inv_1_24.Y sky130_hd_ro32_nand_0.sky130_hd_inv_1_23.Y uo_out[7] sky130_fd_pr__nfet_01v8 ad=0.169 pd=1.82 as=0.0878 ps=0.92 w=0.65 l=0.15
X822 sky130_hd_ro37_nand_0.sky130_hd_inv_1_9.Y sky130_hd_ro37_nand_0.sky130_hd_inv_1_10.Y VDPWR VDPWR sky130_fd_pr__pfet_01v8 ad=0.135 pd=1.27 as=0.26 ps=2.52 w=1 l=0.15
X823 sky130_hd_ro47_nand_0.sky130_hd_inv_1_19.Y sky130_hd_ro47_nand_0.sky130_hd_inv_1_20.Y uo_out[7] uo_out[7] sky130_fd_pr__nfet_01v8 ad=0.0878 pd=0.92 as=0.169 ps=1.82 w=0.65 l=0.15
X824 sky130_hd_ro53_nand_0.sky130_hd_inv_1_10.Y sky130_hd_ro53_nand_0.sky130_hd_inv_1_11.Y VDPWR VDPWR sky130_fd_pr__pfet_01v8 ad=0.135 pd=1.27 as=0.26 ps=2.52 w=1 l=0.15
X825 VDPWR sky130_hd_ro41_nand_0.sky130_hd_inv_1_31.Y sky130_hd_ro41_nand_0.sky130_hd_inv_1_30.Y VDPWR sky130_fd_pr__pfet_01v8 ad=0.26 pd=2.52 as=0.135 ps=1.27 w=1 l=0.15
X826 uo_out[7] sky130_hd_ro41_nand_0.sky130_hd_inv_1_31.Y sky130_hd_ro41_nand_0.sky130_hd_inv_1_30.Y uo_out[7] sky130_fd_pr__nfet_01v8 ad=0.169 pd=1.82 as=0.0878 ps=0.92 w=0.65 l=0.15
X827 VDPWR a_27999_3091# a_27926_3345# VDPWR sky130_fd_pr__pfet_01v8_hvt ad=0.179 pd=1.26 as=0.0767 ps=0.785 w=0.42 l=0.15
X828 VDPWR sky130_hd_ro47_nand_0.sky130_hd_inv_1_15.A sky130_hd_ro47_nand_0.sky130_hd_inv_1_16.A VDPWR sky130_fd_pr__pfet_01v8 ad=0.26 pd=2.52 as=0.135 ps=1.27 w=1 l=0.15
X829 sky130_hd_ro47_nand_0.sky130_hd_inv_1_44.Y sky130_hd_ro47_nand_0.sky130_hd_inv_1_45.Y VDPWR VDPWR sky130_fd_pr__pfet_01v8 ad=0.135 pd=1.27 as=0.26 ps=2.52 w=1 l=0.15
X830 uo_out[0] sky130_hd_inv_4_0.A VDPWR VDPWR sky130_fd_pr__pfet_01v8_hvt ad=0.135 pd=1.27 as=0.135 ps=1.27 w=1 l=0.15
X831 a_22414_35563# a_22194_35563# uo_out[7] uo_out[7] sky130_fd_pr__nfet_01v8 ad=0.0696 pd=0.765 as=0.121 ps=1.09 w=0.42 l=0.15
X832 sky130_hd_ro33_nand_0.sky130_hd_inv_1_4.Y sky130_hd_ro33_nand_0.sky130_hd_inv_1_5.Y uo_out[7] uo_out[7] sky130_fd_pr__nfet_01v8 ad=0.0878 pd=0.92 as=0.169 ps=1.82 w=0.65 l=0.15
X833 sky130_hd_ro37_nand_0.sky130_hd_inv_1_23.Y sky130_hd_ro37_nand_0.sky130_hd_inv_1_24.Y VDPWR VDPWR sky130_fd_pr__pfet_01v8 ad=0.135 pd=1.27 as=0.26 ps=2.52 w=1 l=0.15
X834 VDPWR sky130_hd_ro33_nand_0.sky130_hd_inv_1_6.Y sky130_hd_ro33_nand_0.sky130_hd_inv_1_5.Y VDPWR sky130_fd_pr__pfet_01v8 ad=0.26 pd=2.52 as=0.135 ps=1.27 w=1 l=0.15
X835 a_27926_3345# a_27392_2979# a_27831_3345# VDPWR sky130_fd_pr__pfet_01v8_hvt ad=0.0767 pd=0.785 as=0.0683 ps=0.745 w=0.42 l=0.15
X836 sky130_hd_ro37_nand_0.sky130_hd_inv_1_14.Y sky130_hd_ro37_nand_0.sky130_hd_inv_1_15.Y VDPWR VDPWR sky130_fd_pr__pfet_01v8 ad=0.135 pd=1.27 as=0.26 ps=2.52 w=1 l=0.15
X837 sky130_hd_ro47_nand_0.sky130_hd_inv_1_43.Y sky130_hd_ro47_nand_0.sky130_hd_inv_1_44.Y uo_out[7] uo_out[7] sky130_fd_pr__nfet_01v8 ad=0.0878 pd=0.92 as=0.169 ps=1.82 w=0.65 l=0.15
X838 VDPWR sky130_hd_ro47_nand_0.sky130_hd_inv_1_30.Y sky130_hd_ro47_nand_0.sky130_hd_inv_1_29.Y VDPWR sky130_fd_pr__pfet_01v8 ad=0.26 pd=2.52 as=0.135 ps=1.27 w=1 l=0.15
X839 a_22058_35537# clk VDPWR VDPWR sky130_fd_pr__pfet_01v8_hvt ad=0.166 pd=1.8 as=0.0864 ps=0.91 w=0.64 l=0.15
X840 sky130_hd_ro37_nand_0.sky130_hd_inv_1_26.Y sky130_hd_ro37_nand_0.sky130_hd_inv_1_27.Y VDPWR VDPWR sky130_fd_pr__pfet_01v8 ad=0.135 pd=1.27 as=0.26 ps=2.52 w=1 l=0.15
X841 sky130_hd_ro41_nand_0.sky130_hd_inv_1_29.A sky130_hd_ro41_nand_0.sky130_hd_inv_1_30.Y VDPWR VDPWR sky130_fd_pr__pfet_01v8 ad=0.135 pd=1.27 as=0.26 ps=2.52 w=1 l=0.15
X842 VDPWR sky130_hd_ro47_nand_0.sky130_hd_inv_1_10.A sky130_hd_ro47_nand_0.sky130_hd_inv_1_11.A VDPWR sky130_fd_pr__pfet_01v8 ad=0.26 pd=2.52 as=0.135 ps=1.27 w=1 l=0.15
X843 sky130_hd_ro53_nand_0.sky130_hd_inv_1_39.Y sky130_hd_ro53_nand_0.sky130_hd_inv_1_40.Y uo_out[7] uo_out[7] sky130_fd_pr__nfet_01v8 ad=0.0878 pd=0.92 as=0.169 ps=1.82 w=0.65 l=0.15
X844 VDPWR sky130_hd_ro33_nand_0.sky130_hd_inv_1_20.Y sky130_hd_ro33_nand_0.sky130_hd_inv_1_19.Y VDPWR sky130_fd_pr__pfet_01v8 ad=0.26 pd=2.52 as=0.135 ps=1.27 w=1 l=0.15
X845 VDPWR sky130_hd_ro37_nand_0.sky130_hd_inv_1_8.Y sky130_hd_ro37_nand_0.sky130_hd_inv_1_1.A VDPWR sky130_fd_pr__pfet_01v8 ad=0.26 pd=2.52 as=0.135 ps=1.27 w=1 l=0.15
X846 sky130_hd_ro41_nand_0.sky130_hd_inv_1_29.A sky130_hd_ro41_nand_0.sky130_hd_inv_1_30.Y uo_out[7] uo_out[7] sky130_fd_pr__nfet_01v8 ad=0.0878 pd=0.92 as=0.169 ps=1.82 w=0.65 l=0.15
X847 VDPWR sky130_hd_ro32_nand_0.sky130_hd_inv_1_3.Y sky130_hd_ro32_nand_0.sky130_hd_inv_1_2.Y VDPWR sky130_fd_pr__pfet_01v8 ad=0.26 pd=2.52 as=0.135 ps=1.27 w=1 l=0.15
X848 VDPWR sky130_hd_xor_block_3.XOROUT sky130_hd_xor_block_2.sky130_hd_inv_1_3.A VDPWR sky130_fd_pr__pfet_01v8 ad=0.26 pd=2.52 as=0.135 ps=1.27 w=1 l=0.15
X849 VDPWR sky130_hd_xor_block_3.XORB sky130_hd_ro37_nand_0.sky130_hd_nand2_1_0.Y VDPWR sky130_fd_pr__pfet_01v8 ad=0.26 pd=2.52 as=0.135 ps=1.27 w=1 l=0.15
X850 VDPWR sky130_hd_xor_block_1.sky130_hd_xor2_1_0.B a_23186_31990# VDPWR sky130_fd_pr__pfet_01v8 ad=0.26 pd=2.52 as=0.135 ps=1.27 w=1 l=0.15
X851 sky130_hd_ro47_nand_0.sky130_hd_inv_1_32.Y sky130_hd_ro47_nand_0.sky130_hd_inv_1_33.Y uo_out[7] uo_out[7] sky130_fd_pr__nfet_01v8 ad=0.0878 pd=0.92 as=0.169 ps=1.82 w=0.65 l=0.15
X852 sky130_hd_ro53_nand_0.sky130_hd_inv_1_13.A sky130_hd_ro53_nand_0.sky130_hd_inv_1_24.Y uo_out[7] uo_out[7] sky130_fd_pr__nfet_01v8 ad=0.0878 pd=0.92 as=0.169 ps=1.82 w=0.65 l=0.15
X853 sky130_hd_xor_block_1.sky130_hd_inv_1_1.Y sky130_hd_xor_block_1.XORB uo_out[7] uo_out[7] sky130_fd_pr__nfet_01v8 ad=0.0878 pd=0.92 as=0.169 ps=1.82 w=0.65 l=0.15
X854 sky130_hd_ro41_nand_0.sky130_hd_inv_1_33.Y sky130_hd_ro41_nand_0.sky130_hd_inv_1_34.Y VDPWR VDPWR sky130_fd_pr__pfet_01v8 ad=0.135 pd=1.27 as=0.26 ps=2.52 w=1 l=0.15
X855 a_27903_1579# a_28188_1565# a_28123_1713# uo_out[7] sky130_fd_pr__special_nfet_01v8 ad=0.0684 pd=0.74 as=0.066 ps=0.745 w=0.36 l=0.15
X856 VDPWR sky130_hd_ro33_nand_0.sky130_hd_inv_1_24.Y sky130_hd_ro33_nand_0.sky130_hd_inv_1_23.Y VDPWR sky130_fd_pr__pfet_01v8 ad=0.26 pd=2.52 as=0.135 ps=1.27 w=1 l=0.15
X857 sky130_hd_xor_block_0.sky130_hd_inv_1_3.A sky130_hd_xor_block_1.XOROUT VDPWR VDPWR sky130_fd_pr__pfet_01v8 ad=0.135 pd=1.27 as=0.26 ps=2.52 w=1 l=0.15
X858 sky130_hd_ro41_nand_0.sky130_hd_inv_1_33.Y sky130_hd_ro41_nand_0.sky130_hd_inv_1_34.Y uo_out[7] uo_out[7] sky130_fd_pr__nfet_01v8 ad=0.0878 pd=0.92 as=0.169 ps=1.82 w=0.65 l=0.15
X859 uo_out[7] sky130_hd_div_by_2_2.Qb a_28742_2813# uo_out[7] sky130_fd_pr__nfet_01v8 ad=0.109 pd=1.36 as=0.0813 ps=0.83 w=0.42 l=0.15
X860 a_27903_3755# a_28195_3645# a_28146_3523# VDPWR sky130_fd_pr__pfet_01v8_hvt ad=0.0567 pd=0.69 as=0.0882 ps=0.84 w=0.42 l=0.15
X861 sky130_hd_ro33_nand_0.sky130_hd_nand2_1_0.Y sky130_hd_xor_block_3.XORA a_8679_33959# uo_out[7] sky130_fd_pr__nfet_01v8 ad=0.169 pd=1.82 as=0.0878 ps=0.92 w=0.65 l=0.15
X862 sky130_hd_ro32_nand_0.sky130_hd_inv_1_2.Y sky130_hd_ro32_nand_0.sky130_hd_inv_1_3.Y uo_out[7] uo_out[7] sky130_fd_pr__nfet_01v8 ad=0.0878 pd=0.92 as=0.169 ps=1.82 w=0.65 l=0.15
X863 VDPWR sky130_hd_ro37_nand_0.sky130_hd_inv_1_32.Y sky130_hd_ro37_nand_0.sky130_hd_inv_1_31.Y VDPWR sky130_fd_pr__pfet_01v8 ad=0.26 pd=2.52 as=0.135 ps=1.27 w=1 l=0.15
X864 a_27631_3850# a_27903_3755# VDPWR VDPWR sky130_fd_pr__pfet_01v8_hvt ad=0.27 pd=2.54 as=0.135 ps=1.27 w=1 l=0.15
X865 uo_out[7] sky130_hd_ro53_nand_0.sky130_hd_inv_1_38.Y sky130_hd_ro53_nand_0.sky130_hd_inv_1_37.Y uo_out[7] sky130_fd_pr__nfet_01v8 ad=0.169 pd=1.82 as=0.0878 ps=0.92 w=0.65 l=0.15
X866 sky130_hd_ro33_nand_0.sky130_hd_inv_1_1.Y sky130_hd_ro33_nand_0.sky130_hd_inv_1_2.Y uo_out[7] uo_out[7] sky130_fd_pr__nfet_01v8 ad=0.0878 pd=0.92 as=0.169 ps=1.82 w=0.65 l=0.15
X867 sky130_hd_ro37_nand_0.sky130_hd_inv_1_21.Y sky130_hd_ro37_nand_0.sky130_hd_inv_1_22.Y uo_out[7] uo_out[7] sky130_fd_pr__nfet_01v8 ad=0.0878 pd=0.92 as=0.169 ps=1.82 w=0.65 l=0.15
X868 VDPWR sky130_hd_ro33_nand_0.sky130_hd_inv_1_3.Y sky130_hd_ro33_nand_0.sky130_hd_inv_1_2.Y VDPWR sky130_fd_pr__pfet_01v8 ad=0.26 pd=2.52 as=0.135 ps=1.27 w=1 l=0.15
X869 sky130_hd_ro33_nand_0.sky130_hd_inv_1_31.Y sky130_hd_ro33_nand_0.sky130_hd_nand2_1_0.Y uo_out[7] uo_out[7] sky130_fd_pr__nfet_01v8 ad=0.0878 pd=0.92 as=0.169 ps=1.82 w=0.65 l=0.15
X870 uo_out[7] sky130_hd_ro47_nand_0.sky130_hd_inv_1_4.Y sky130_hd_ro47_nand_0.sky130_hd_inv_1_3.Y uo_out[7] sky130_fd_pr__nfet_01v8 ad=0.169 pd=1.82 as=0.0878 ps=0.92 w=0.65 l=0.15
X871 VDPWR sky130_hd_ro53_nand_0.sky130_hd_inv_1_39.Y sky130_hd_ro53_nand_0.sky130_hd_inv_1_38.Y VDPWR sky130_fd_pr__pfet_01v8 ad=0.26 pd=2.52 as=0.135 ps=1.27 w=1 l=0.15
X872 a_23018_31990# sky130_hd_xor_block_1.sky130_hd_xor2_1_0.B a_22936_31990# VDPWR sky130_fd_pr__pfet_01v8 ad=0.135 pd=1.27 as=0.26 ps=2.52 w=1 l=0.15
X873 sky130_hd_ro47_nand_0.sky130_hd_inv_1_40.Y sky130_hd_ro47_nand_0.sky130_hd_inv_1_41.Y uo_out[7] uo_out[7] sky130_fd_pr__nfet_01v8 ad=0.0878 pd=0.92 as=0.169 ps=1.82 w=0.65 l=0.15
X874 sky130_hd_ro53_nand_0.sky130_hd_inv_1_11.Y sky130_hd_ro53_nand_0.sky130_hd_inv_1_22.Y VDPWR VDPWR sky130_fd_pr__pfet_01v8 ad=0.135 pd=1.27 as=0.26 ps=2.52 w=1 l=0.15
X875 sky130_hd_ro32_nand_0.sky130_hd_inv_1_6.Y sky130_hd_ro32_nand_0.sky130_hd_inv_1_7.Y VDPWR VDPWR sky130_fd_pr__pfet_01v8 ad=0.135 pd=1.27 as=0.26 ps=2.52 w=1 l=0.15
X876 a_24259_35563# a_24130_35837# a_23839_35537# uo_out[7] sky130_fd_pr__special_nfet_01v8 ad=0.0989 pd=0.995 as=0.0684 ps=0.74 w=0.36 l=0.15
X877 sky130_hd_ro33_nand_0.sky130_hd_inv_1_15.Y sky130_hd_ro33_nand_0.sky130_hd_inv_1_16.Y uo_out[7] uo_out[7] sky130_fd_pr__nfet_01v8 ad=0.0878 pd=0.92 as=0.169 ps=1.82 w=0.65 l=0.15
X878 VDPWR sky130_hd_ro47_nand_0.sky130_hd_inv_1_13.A sky130_hd_ro47_nand_0.sky130_hd_inv_1_14.A VDPWR sky130_fd_pr__pfet_01v8 ad=0.26 pd=2.52 as=0.135 ps=1.27 w=1 l=0.15
X879 a_28146_2435# a_27631_2762# VDPWR VDPWR sky130_fd_pr__pfet_01v8_hvt ad=0.0882 pd=0.84 as=0.111 ps=1.37 w=0.42 l=0.15
X880 uo_out[7] a_23743_35715# sky130_hd_dfxtp_1_1.Q uo_out[7] sky130_fd_pr__nfet_01v8 ad=0.0878 pd=0.92 as=0.169 ps=1.82 w=0.65 l=0.15
X881 a_24950_30833# sky130_hd_xor_block_0.sky130_hd_xor2_1_0.B a_24868_30833# VDPWR sky130_fd_pr__pfet_01v8 ad=0.135 pd=1.27 as=0.26 ps=2.52 w=1 l=0.15
X882 VDPWR sky130_hd_ro41_nand_0.sky130_hd_inv_1_7.A sky130_hd_ro41_nand_0.sky130_hd_inv_1_8.A VDPWR sky130_fd_pr__pfet_01v8 ad=0.26 pd=2.52 as=0.135 ps=1.27 w=1 l=0.15
X883 uo_out[7] sky130_hd_ro47_nand_0.sky130_hd_inv_1_14.A sky130_hd_ro47_nand_0.sky130_hd_inv_1_15.A uo_out[7] sky130_fd_pr__nfet_01v8 ad=0.169 pd=1.82 as=0.0878 ps=0.92 w=0.65 l=0.15
X884 sky130_hd_ro41_nand_0.sky130_hd_inv_1_30.Y sky130_hd_ro41_nand_0.sky130_hd_inv_1_31.Y VDPWR VDPWR sky130_fd_pr__pfet_01v8 ad=0.135 pd=1.27 as=0.26 ps=2.52 w=1 l=0.15
X885 sky130_hd_ro41_nand_0.sky130_hd_inv_1_30.Y sky130_hd_ro41_nand_0.sky130_hd_inv_1_31.Y uo_out[7] uo_out[7] sky130_fd_pr__nfet_01v8 ad=0.0878 pd=0.92 as=0.169 ps=1.82 w=0.65 l=0.15
X886 uo_out[7] sky130_hd_ro41_nand_0.sky130_hd_inv_1_7.A sky130_hd_ro41_nand_0.sky130_hd_inv_1_8.A uo_out[7] sky130_fd_pr__nfet_01v8 ad=0.169 pd=1.82 as=0.0878 ps=0.92 w=0.65 l=0.15
X887 a_28544_2801# a_28324_2813# uo_out[7] uo_out[7] sky130_fd_pr__nfet_01v8 ad=0.0696 pd=0.765 as=0.121 ps=1.09 w=0.42 l=0.15
X888 sky130_hd_ro37_nand_0.sky130_hd_inv_1_33.Y sky130_hd_ro37_nand_0.sky130_hd_inv_1_34.Y uo_out[7] uo_out[7] sky130_fd_pr__nfet_01v8 ad=0.0878 pd=0.92 as=0.169 ps=1.82 w=0.65 l=0.15
X889 VDPWR sky130_hd_ro37_nand_0.sky130_hd_inv_1_29.Y sky130_hd_ro37_nand_0.sky130_hd_inv_1_28.Y VDPWR sky130_fd_pr__pfet_01v8 ad=0.26 pd=2.52 as=0.135 ps=1.27 w=1 l=0.15
X890 VDPWR sky130_hd_ro53_nand_0.sky130_hd_inv_1_32.Y sky130_hd_ro53_nand_0.sky130_hd_inv_1_31.Y VDPWR sky130_fd_pr__pfet_01v8 ad=0.26 pd=2.52 as=0.135 ps=1.27 w=1 l=0.15
X891 uo_out[7] sky130_hd_xor_block_3.XORB sky130_hd_xor_block_3.sky130_hd_inv_1_1.Y uo_out[7] sky130_fd_pr__nfet_01v8 ad=0.169 pd=1.82 as=0.0878 ps=0.92 w=0.65 l=0.15
X892 sky130_hd_ro53_nand_0.sky130_hd_inv_1_4.Y sky130_hd_ro53_nand_0.sky130_hd_inv_1_5.Y VDPWR VDPWR sky130_fd_pr__pfet_01v8 ad=0.135 pd=1.27 as=0.26 ps=2.52 w=1 l=0.15
X893 a_28340_3345# a_27558_2979# a_28256_3345# VDPWR sky130_fd_pr__pfet_01v8_hvt ad=0.0882 pd=0.84 as=0.0567 ps=0.69 w=0.42 l=0.15
X894 uo_out[7] sky130_hd_ro53_nand_0.sky130_hd_inv_1_17.A sky130_hd_ro53_nand_0.sky130_hd_inv_1_18.A uo_out[7] sky130_fd_pr__nfet_01v8 ad=0.169 pd=1.82 as=0.0878 ps=0.92 w=0.65 l=0.15
X895 uo_out[7] sky130_hd_ro53_nand_0.sky130_hd_inv_1_35.Y sky130_hd_ro53_nand_0.sky130_hd_inv_1_34.Y uo_out[7] sky130_fd_pr__nfet_01v8 ad=0.169 pd=1.82 as=0.0878 ps=0.92 w=0.65 l=0.15
X896 sky130_hd_ro53_nand_0.sky130_hd_inv_1_7.Y sky130_hd_ro53_nand_0.sky130_hd_inv_1_8.Y uo_out[7] uo_out[7] sky130_fd_pr__nfet_01v8 ad=0.0878 pd=0.92 as=0.169 ps=1.82 w=0.65 l=0.15
X897 VDPWR sky130_hd_ro33_nand_0.sky130_hd_inv_1_26.Y sky130_hd_ro33_nand_0.sky130_hd_inv_1_25.Y VDPWR sky130_fd_pr__pfet_01v8 ad=0.26 pd=2.52 as=0.135 ps=1.27 w=1 l=0.15
X898 sky130_hd_xor_block_3.sky130_hd_inv_1_3.A sky130_hd_xor_block_3.XORA VDPWR VDPWR sky130_fd_pr__pfet_01v8 ad=0.135 pd=1.27 as=0.26 ps=2.52 w=1 l=0.15
X899 uo_out[7] sky130_hd_ro37_nand_0.sky130_hd_inv_1_5.A sky130_hd_ro37_nand_0.sky130_hd_inv_1_6.A uo_out[7] sky130_fd_pr__nfet_01v8 ad=0.169 pd=1.82 as=0.0878 ps=0.92 w=0.65 l=0.15
X900 sky130_hd_ro47_nand_0.sky130_hd_inv_1_29.Y sky130_hd_ro47_nand_0.sky130_hd_inv_1_30.Y VDPWR VDPWR sky130_fd_pr__pfet_01v8 ad=0.135 pd=1.27 as=0.26 ps=2.52 w=1 l=0.15
X901 VDPWR sky130_hd_ro53_nand_0.sky130_hd_inv_1_36.Y sky130_hd_ro53_nand_0.sky130_hd_inv_1_35.Y VDPWR sky130_fd_pr__pfet_01v8 ad=0.26 pd=2.52 as=0.135 ps=1.27 w=1 l=0.15
X902 sky130_hd_ro32_nand_0.sky130_hd_inv_1_23.Y sky130_hd_ro32_nand_0.sky130_hd_inv_1_24.Y uo_out[7] uo_out[7] sky130_fd_pr__nfet_01v8 ad=0.0878 pd=0.92 as=0.169 ps=1.82 w=0.65 l=0.15
X903 sky130_hd_ro47_nand_0.sky130_hd_inv_1_37.Y sky130_hd_ro47_nand_0.sky130_hd_inv_1_38.Y uo_out[7] uo_out[7] sky130_fd_pr__nfet_01v8 ad=0.0878 pd=0.92 as=0.169 ps=1.82 w=0.65 l=0.15
X904 sky130_hd_ro53_nand_0.sky130_hd_inv_1_8.Y sky130_hd_ro53_nand_0.sky130_hd_inv_1_9.Y VDPWR VDPWR sky130_fd_pr__pfet_01v8 ad=0.135 pd=1.27 as=0.26 ps=2.52 w=1 l=0.15
X905 sky130_hd_div_by_2_3.Q a_28424_3247# VDPWR VDPWR sky130_fd_pr__pfet_01v8_hvt ad=0.26 pd=2.52 as=0.135 ps=1.27 w=1 l=0.15
X906 sky130_hd_ro33_nand_0.sky130_hd_inv_1_19.Y sky130_hd_ro33_nand_0.sky130_hd_inv_1_20.Y VDPWR VDPWR sky130_fd_pr__pfet_01v8 ad=0.135 pd=1.27 as=0.26 ps=2.52 w=1 l=0.15
X907 VDPWR sky130_hd_xor_block_2.sky130_hd_inv_1_1.Y sky130_hd_xor_block_2.sky130_hd_xor2_1_0.A VDPWR sky130_fd_pr__pfet_01v8 ad=0.26 pd=2.52 as=0.135 ps=1.27 w=1 l=0.15
X908 sky130_hd_ro37_nand_0.sky130_hd_inv_1_1.A sky130_hd_ro37_nand_0.sky130_hd_inv_1_8.Y VDPWR VDPWR sky130_fd_pr__pfet_01v8 ad=0.135 pd=1.27 as=0.26 ps=2.52 w=1 l=0.15
X909 a_27536_2409# a_27631_2762# uo_out[7] uo_out[7] sky130_fd_pr__nfet_01v8 ad=0.109 pd=1.36 as=0.097 ps=0.975 w=0.42 l=0.15
X910 VDPWR sky130_hd_ro32_nand_0.sky130_hd_inv_1_18.Y sky130_hd_ro32_nand_0.sky130_hd_inv_1_17.Y VDPWR sky130_fd_pr__pfet_01v8 ad=0.26 pd=2.52 as=0.135 ps=1.27 w=1 l=0.15
X911 uo_out[7] sky130_hd_ro53_nand_0.sky130_hd_inv_1_13.A sky130_hd_ro53_nand_0.sky130_hd_inv_1_14.A uo_out[7] sky130_fd_pr__nfet_01v8 ad=0.169 pd=1.82 as=0.0878 ps=0.92 w=0.65 l=0.15
X912 sky130_hd_ro37_nand_0.sky130_hd_nand2_1_0.Y ui_in[4] VDPWR VDPWR sky130_fd_pr__pfet_01v8 ad=0.135 pd=1.27 as=0.26 ps=2.52 w=1 l=0.15
X913 a_23186_31990# sky130_hd_xor_block_1.sky130_hd_xor2_1_0.A VDPWR VDPWR sky130_fd_pr__pfet_01v8 ad=0.135 pd=1.27 as=0.135 ps=1.27 w=1 l=0.15
X914 VDPWR sky130_hd_ro47_nand_0.sky130_hd_inv_1_16.A sky130_hd_ro47_nand_0.sky130_hd_inv_1_16.Y VDPWR sky130_fd_pr__pfet_01v8 ad=0.26 pd=2.52 as=0.135 ps=1.27 w=1 l=0.15
X915 a_4631_27642# ui_in[6] uo_out[7] uo_out[7] sky130_fd_pr__nfet_01v8 ad=0.0878 pd=0.92 as=0.169 ps=1.82 w=0.65 l=0.15
X916 a_28324_2813# a_28188_2653# a_27903_2667# VDPWR sky130_fd_pr__pfet_01v8_hvt ad=0.109 pd=1.08 as=0.0567 ps=0.69 w=0.42 l=0.15
X917 a_28324_3901# a_28195_3645# a_27903_3755# uo_out[7] sky130_fd_pr__special_nfet_01v8 ad=0.0989 pd=0.995 as=0.0684 ps=0.74 w=0.36 l=0.15
X918 a_22612_35563# a_22065_35837# a_22265_35537# VDPWR sky130_fd_pr__pfet_01v8_hvt ad=0.0578 pd=0.695 as=0.0683 ps=0.745 w=0.42 l=0.15
X919 VDPWR sky130_hd_ro53_nand_0.sky130_hd_inv_1_49.Y sky130_hd_ro53_nand_0.sky130_hd_inv_1_48.Y VDPWR sky130_fd_pr__pfet_01v8 ad=0.26 pd=2.52 as=0.135 ps=1.27 w=1 l=0.15
X920 uo_out[7] sky130_hd_ro32_nand_0.sky130_hd_inv_1_11.Y sky130_hd_ro32_nand_0.sky130_hd_inv_1_10.Y uo_out[7] sky130_fd_pr__nfet_01v8 ad=0.169 pd=1.82 as=0.0878 ps=0.92 w=0.65 l=0.15
X921 sky130_hd_ro32_nand_0.sky130_hd_inv_1_20.Y sky130_hd_ro32_nand_0.sky130_hd_inv_1_21.Y uo_out[7] uo_out[7] sky130_fd_pr__nfet_01v8 ad=0.0878 pd=0.92 as=0.169 ps=1.82 w=0.65 l=0.15
X922 a_21179_33268# sky130_hd_xor_block_2.sky130_hd_xor2_1_0.B uo_out[7] uo_out[7] sky130_fd_pr__nfet_01v8 ad=0.0878 pd=0.92 as=0.169 ps=1.82 w=0.65 l=0.15
X923 VDPWR sky130_hd_ro41_nand_0.sky130_hd_inv_1_18.Y sky130_hd_ro41_nand_0.sky130_hd_inv_1_17.Y VDPWR sky130_fd_pr__pfet_01v8 ad=0.26 pd=2.52 as=0.135 ps=1.27 w=1 l=0.15
X924 sky130_hd_ro32_nand_0.sky130_hd_inv_1_27.Y sky130_hd_ro32_nand_0.sky130_hd_inv_1_28.Y VDPWR VDPWR sky130_fd_pr__pfet_01v8 ad=0.135 pd=1.27 as=0.26 ps=2.52 w=1 l=0.15
X925 a_22194_35563# a_22058_35537# a_21774_35537# VDPWR sky130_fd_pr__pfet_01v8_hvt ad=0.109 pd=1.08 as=0.0567 ps=0.69 w=0.42 l=0.15
X926 uo_out[7] sky130_hd_ro41_nand_0.sky130_hd_inv_1_18.Y sky130_hd_ro41_nand_0.sky130_hd_inv_1_17.Y uo_out[7] sky130_fd_pr__nfet_01v8 ad=0.169 pd=1.82 as=0.0878 ps=0.92 w=0.65 l=0.15
X927 uo_out[7] sky130_hd_ro47_nand_0.sky130_hd_inv_1_16.Y sky130_hd_ro47_nand_0.sky130_hd_inv_1_5.Y uo_out[7] sky130_fd_pr__nfet_01v8 ad=0.169 pd=1.82 as=0.0878 ps=0.92 w=0.65 l=0.15
X928 VDPWR sky130_hd_ro53_nand_0.sky130_hd_inv_1_41.Y sky130_hd_ro53_nand_0.sky130_hd_inv_1_40.Y VDPWR sky130_fd_pr__pfet_01v8 ad=0.26 pd=2.52 as=0.135 ps=1.27 w=1 l=0.15
X929 VDPWR sky130_hd_ro32_nand_0.sky130_hd_inv_1_15.Y sky130_hd_ro32_nand_0.sky130_hd_inv_1_14.Y VDPWR sky130_fd_pr__pfet_01v8 ad=0.26 pd=2.52 as=0.135 ps=1.27 w=1 l=0.15
X930 a_8679_33959# ui_in[3] uo_out[7] uo_out[7] sky130_fd_pr__nfet_01v8 ad=0.0878 pd=0.92 as=0.169 ps=1.82 w=0.65 l=0.15
X931 sky130_hd_ro47_nand_0.sky130_hd_inv_1_42.Y sky130_hd_ro47_nand_0.sky130_hd_inv_1_43.Y uo_out[7] uo_out[7] sky130_fd_pr__nfet_01v8 ad=0.0878 pd=0.92 as=0.169 ps=1.82 w=0.65 l=0.15
X932 sky130_hd_div_by_2_1.CLK a_28424_2159# VDPWR VDPWR sky130_fd_pr__pfet_01v8_hvt ad=0.26 pd=2.52 as=0.135 ps=1.27 w=1 l=0.15
X933 a_27558_2979# a_27392_2979# uo_out[7] uo_out[7] sky130_fd_pr__nfet_01v8 ad=0.109 pd=1.36 as=0.0567 ps=0.69 w=0.42 l=0.15
X934 uo_out[7] sky130_hd_ro53_nand_0.sky130_hd_inv_1_43.Y sky130_hd_ro53_nand_0.sky130_hd_inv_1_42.Y uo_out[7] sky130_fd_pr__nfet_01v8 ad=0.169 pd=1.82 as=0.0878 ps=0.92 w=0.65 l=0.15
X935 sky130_hd_xor_block_2.XOROUT sky130_hd_xor_block_2.sky130_hd_xor2_1_0.B a_21429_33018# uo_out[7] sky130_fd_pr__nfet_01v8 ad=0.25 pd=1.42 as=0.0878 ps=0.92 w=0.65 l=0.15
X936 sky130_hd_ro32_nand_0.sky130_hd_inv_1_17.Y sky130_hd_ro32_nand_0.sky130_hd_inv_1_18.Y uo_out[7] uo_out[7] sky130_fd_pr__nfet_01v8 ad=0.0878 pd=0.92 as=0.169 ps=1.82 w=0.65 l=0.15
X937 sky130_hd_ro32_nand_0.sky130_hd_inv_1_24.Y sky130_hd_ro32_nand_0.sky130_hd_inv_1_25.Y VDPWR VDPWR sky130_fd_pr__pfet_01v8 ad=0.135 pd=1.27 as=0.26 ps=2.52 w=1 l=0.15
X938 uo_out[7] sky130_hd_ro37_nand_0.sky130_hd_inv_1_25.Y sky130_hd_ro37_nand_0.sky130_hd_inv_1_24.Y uo_out[7] sky130_fd_pr__nfet_01v8 ad=0.169 pd=1.82 as=0.0878 ps=0.92 w=0.65 l=0.15
X939 a_27536_2409# a_27631_2762# VDPWR VDPWR sky130_fd_pr__pfet_01v8_hvt ad=0.166 pd=1.8 as=0.154 ps=1.34 w=0.64 l=0.15
X940 uo_out[7] sky130_hd_ro53_nand_0.sky130_hd_inv_1_20.A sky130_hd_ro53_nand_0.sky130_hd_inv_1_21.A uo_out[7] sky130_fd_pr__nfet_01v8 ad=0.169 pd=1.82 as=0.0878 ps=0.92 w=0.65 l=0.15
X941 VDPWR sky130_hd_ro33_nand_0.sky130_hd_inv_1_23.Y sky130_hd_ro33_nand_0.sky130_hd_inv_1_22.Y VDPWR sky130_fd_pr__pfet_01v8 ad=0.26 pd=2.52 as=0.135 ps=1.27 w=1 l=0.15
X942 uo_out[7] sky130_hd_ro47_nand_0.sky130_hd_inv_1_25.Y sky130_hd_ro47_nand_0.sky130_hd_inv_1_24.Y uo_out[7] sky130_fd_pr__nfet_01v8 ad=0.169 pd=1.82 as=0.0878 ps=0.92 w=0.65 l=0.15
X943 a_27558_1891# a_27392_1891# uo_out[7] uo_out[7] sky130_fd_pr__nfet_01v8 ad=0.109 pd=1.36 as=0.0567 ps=0.69 w=0.42 l=0.15
X944 a_27558_2979# a_27392_2979# VDPWR VDPWR sky130_fd_pr__pfet_01v8_hvt ad=0.166 pd=1.8 as=0.0864 ps=0.91 w=0.64 l=0.15
X945 sky130_hd_ro32_nand_0.sky130_hd_inv_1_21.Y sky130_hd_ro32_nand_0.sky130_hd_inv_1_22.Y VDPWR VDPWR sky130_fd_pr__pfet_01v8 ad=0.135 pd=1.27 as=0.26 ps=2.52 w=1 l=0.15
X946 sky130_hd_ro47_nand_0.sky130_hd_inv_1_14.A sky130_hd_ro47_nand_0.sky130_hd_inv_1_13.A VDPWR VDPWR sky130_fd_pr__pfet_01v8 ad=0.135 pd=1.27 as=0.26 ps=2.52 w=1 l=0.15
X947 sky130_hd_ro53_nand_0.sky130_hd_inv_1_5.Y sky130_hd_ro53_nand_0.sky130_hd_inv_1_6.Y VDPWR VDPWR sky130_fd_pr__pfet_01v8 ad=0.135 pd=1.27 as=0.26 ps=2.52 w=1 l=0.15
X948 sky130_hd_ro33_nand_0.sky130_hd_inv_1_16.Y sky130_hd_ro33_nand_0.sky130_hd_inv_1_17.Y VDPWR VDPWR sky130_fd_pr__pfet_01v8 ad=0.135 pd=1.27 as=0.26 ps=2.52 w=1 l=0.15
X949 sky130_hd_ro37_nand_0.sky130_hd_inv_1_34.Y sky130_hd_ro37_nand_0.sky130_hd_inv_1_35.Y uo_out[7] uo_out[7] sky130_fd_pr__nfet_01v8 ad=0.0878 pd=0.92 as=0.169 ps=1.82 w=0.65 l=0.15
X950 VDPWR sky130_hd_ro41_nand_0.sky130_hd_inv_1_1.A sky130_hd_ro41_nand_0.sky130_hd_inv_1_2.A VDPWR sky130_fd_pr__pfet_01v8 ad=0.26 pd=2.52 as=0.135 ps=1.27 w=1 l=0.15
X951 sky130_hd_ro53_nand_0.sky130_hd_inv_1_51.Y sky130_hd_ro53_nand_0.sky130_hd_nand2_1_0.Y VDPWR VDPWR sky130_fd_pr__pfet_01v8 ad=0.135 pd=1.27 as=0.26 ps=2.52 w=1 l=0.15
X952 uo_out[7] sky130_hd_ro41_nand_0.sky130_hd_inv_1_1.A sky130_hd_ro41_nand_0.sky130_hd_inv_1_2.A uo_out[7] sky130_fd_pr__nfet_01v8 ad=0.169 pd=1.82 as=0.0878 ps=0.92 w=0.65 l=0.15
X953 sky130_hd_xor_block_1.sky130_hd_inv_1_3.A sky130_hd_xor_block_2.XOROUT VDPWR VDPWR sky130_fd_pr__pfet_01v8 ad=0.135 pd=1.27 as=0.26 ps=2.52 w=1 l=0.15
X954 sky130_hd_ro41_nand_0.sky130_hd_inv_1_8.A sky130_hd_ro41_nand_0.sky130_hd_inv_1_7.A VDPWR VDPWR sky130_fd_pr__pfet_01v8 ad=0.135 pd=1.27 as=0.26 ps=2.52 w=1 l=0.15
X955 uo_out[7] sky130_hd_ro47_nand_0.sky130_hd_inv_1_29.Y sky130_hd_ro47_nand_0.sky130_hd_inv_1_28.Y uo_out[7] sky130_fd_pr__nfet_01v8 ad=0.169 pd=1.82 as=0.0878 ps=0.92 w=0.65 l=0.15
X956 sky130_hd_ro41_nand_0.sky130_hd_inv_1_8.A sky130_hd_ro41_nand_0.sky130_hd_inv_1_7.A uo_out[7] uo_out[7] sky130_fd_pr__nfet_01v8 ad=0.0878 pd=0.92 as=0.169 ps=1.82 w=0.65 l=0.15
X957 sky130_hd_ro47_nand_0.sky130_hd_inv_1_39.Y sky130_hd_ro47_nand_0.sky130_hd_inv_1_40.Y VDPWR VDPWR sky130_fd_pr__pfet_01v8 ad=0.135 pd=1.27 as=0.26 ps=2.52 w=1 l=0.15
X958 uo_out[7] sky130_hd_ro53_nand_0.sky130_hd_inv_1_15.A sky130_hd_ro53_nand_0.sky130_hd_inv_1_16.A uo_out[7] sky130_fd_pr__nfet_01v8 ad=0.169 pd=1.82 as=0.0878 ps=0.92 w=0.65 l=0.15
X959 sky130_hd_ro37_nand_0.sky130_hd_inv_1_18.Y sky130_hd_ro37_nand_0.sky130_hd_inv_1_19.Y VDPWR VDPWR sky130_fd_pr__pfet_01v8 ad=0.135 pd=1.27 as=0.26 ps=2.52 w=1 l=0.15
X960 VDPWR sky130_hd_ro41_nand_0.sky130_hd_inv_1_15.Y sky130_hd_ro41_nand_0.sky130_hd_inv_1_14.Y VDPWR sky130_fd_pr__pfet_01v8 ad=0.26 pd=2.52 as=0.135 ps=1.27 w=1 l=0.15
X961 uo_out[7] sky130_hd_ro47_nand_0.sky130_hd_inv_1_3.Y sky130_hd_ro47_nand_0.sky130_hd_inv_1_2.Y uo_out[7] sky130_fd_pr__nfet_01v8 ad=0.169 pd=1.82 as=0.0878 ps=0.92 w=0.65 l=0.15
X962 sky130_hd_ro53_nand_0.sky130_hd_inv_1_30.Y sky130_hd_ro53_nand_0.sky130_hd_inv_1_31.Y uo_out[7] uo_out[7] sky130_fd_pr__nfet_01v8 ad=0.0878 pd=0.92 as=0.169 ps=1.82 w=0.65 l=0.15
X963 VDPWR sky130_hd_ro33_nand_0.sky130_hd_inv_1_1.Y sky130_hd_xor_block_3.XORA VDPWR sky130_fd_pr__pfet_01v8 ad=0.26 pd=2.52 as=0.135 ps=1.27 w=1 l=0.15
X964 sky130_hd_xor_block_1.sky130_hd_xor2_1_0.B sky130_hd_xor_block_1.sky130_hd_inv_1_3.A uo_out[7] uo_out[7] sky130_fd_pr__nfet_01v8 ad=0.0878 pd=0.92 as=0.169 ps=1.82 w=0.65 l=0.15
X965 uo_out[7] sky130_hd_ro41_nand_0.sky130_hd_inv_1_15.Y sky130_hd_ro41_nand_0.sky130_hd_inv_1_14.Y uo_out[7] sky130_fd_pr__nfet_01v8 ad=0.169 pd=1.82 as=0.0878 ps=0.92 w=0.65 l=0.15
X966 sky130_hd_ro53_nand_0.sky130_hd_inv_1_31.Y sky130_hd_ro53_nand_0.sky130_hd_inv_1_32.Y VDPWR VDPWR sky130_fd_pr__pfet_01v8 ad=0.135 pd=1.27 as=0.26 ps=2.52 w=1 l=0.15
X967 sky130_hd_ro33_nand_0.sky130_hd_inv_1_21.Y sky130_hd_ro33_nand_0.sky130_hd_inv_1_22.Y VDPWR VDPWR sky130_fd_pr__pfet_01v8 ad=0.135 pd=1.27 as=0.26 ps=2.52 w=1 l=0.15
X968 sky130_hd_ro53_nand_0.sky130_hd_inv_1_24.Y sky130_hd_ro53_nand_0.sky130_hd_inv_1_25.Y VDPWR VDPWR sky130_fd_pr__pfet_01v8 ad=0.135 pd=1.27 as=0.26 ps=2.52 w=1 l=0.15
X969 sky130_hd_ro53_nand_0.sky130_hd_inv_1_34.Y sky130_hd_ro53_nand_0.sky130_hd_inv_1_35.Y uo_out[7] uo_out[7] sky130_fd_pr__nfet_01v8 ad=0.0878 pd=0.92 as=0.169 ps=1.82 w=0.65 l=0.15
X970 VDPWR sky130_hd_ro41_nand_0.sky130_hd_inv_1_29.Y sky130_hd_ro41_nand_0.sky130_hd_inv_1_28.Y VDPWR sky130_fd_pr__pfet_01v8 ad=0.26 pd=2.52 as=0.135 ps=1.27 w=1 l=0.15
X971 uo_out[7] sky130_hd_ro41_nand_0.sky130_hd_inv_1_29.Y sky130_hd_ro41_nand_0.sky130_hd_inv_1_28.Y uo_out[7] sky130_fd_pr__nfet_01v8 ad=0.169 pd=1.82 as=0.0878 ps=0.92 w=0.65 l=0.15
X972 sky130_hd_ro33_nand_0.sky130_hd_inv_1_25.Y sky130_hd_ro33_nand_0.sky130_hd_inv_1_26.Y VDPWR VDPWR sky130_fd_pr__pfet_01v8 ad=0.135 pd=1.27 as=0.26 ps=2.52 w=1 l=0.15
X973 VDPWR sky130_hd_ro41_nand_0.sky130_hd_inv_1_20.Y sky130_hd_ro41_nand_0.sky130_hd_inv_1_19.Y VDPWR sky130_fd_pr__pfet_01v8 ad=0.26 pd=2.52 as=0.135 ps=1.27 w=1 l=0.15
X974 uo_out[7] sky130_hd_ro41_nand_0.sky130_hd_inv_1_20.Y sky130_hd_ro41_nand_0.sky130_hd_inv_1_19.Y uo_out[7] sky130_fd_pr__nfet_01v8 ad=0.169 pd=1.82 as=0.0878 ps=0.92 w=0.65 l=0.15
X975 uo_out[7] sky130_hd_ro32_nand_0.sky130_hd_inv_1_29.Y sky130_hd_ro32_nand_0.sky130_hd_inv_1_28.Y uo_out[7] sky130_fd_pr__nfet_01v8 ad=0.169 pd=1.82 as=0.0878 ps=0.92 w=0.65 l=0.15
X976 sky130_hd_ro53_nand_0.sky130_hd_inv_1_47.Y sky130_hd_ro53_nand_0.sky130_hd_inv_1_48.Y uo_out[7] uo_out[7] sky130_fd_pr__nfet_01v8 ad=0.0878 pd=0.92 as=0.169 ps=1.82 w=0.65 l=0.15
X977 sky130_hd_ro47_nand_0.sky130_hd_inv_1_16.Y sky130_hd_ro47_nand_0.sky130_hd_inv_1_16.A VDPWR VDPWR sky130_fd_pr__pfet_01v8 ad=0.135 pd=1.27 as=0.26 ps=2.52 w=1 l=0.15
X978 uo_out[7] sky130_hd_ro47_nand_0.sky130_hd_inv_1_22.Y sky130_hd_ro47_nand_0.sky130_hd_inv_1_21.Y uo_out[7] sky130_fd_pr__nfet_01v8 ad=0.169 pd=1.82 as=0.0878 ps=0.92 w=0.65 l=0.15
X979 sky130_hd_ro37_nand_0.sky130_hd_inv_1_31.Y sky130_hd_ro37_nand_0.sky130_hd_inv_1_32.Y uo_out[7] uo_out[7] sky130_fd_pr__nfet_01v8 ad=0.0878 pd=0.92 as=0.169 ps=1.82 w=0.65 l=0.15
X980 a_28188_3741# ua[0] VDPWR VDPWR sky130_fd_pr__pfet_01v8_hvt ad=0.166 pd=1.8 as=0.0864 ps=0.91 w=0.64 l=0.15
X981 sky130_hd_ro33_nand_0.sky130_hd_inv_1_13.Y sky130_hd_ro33_nand_0.sky130_hd_inv_1_14.Y VDPWR VDPWR sky130_fd_pr__pfet_01v8 ad=0.135 pd=1.27 as=0.26 ps=2.52 w=1 l=0.15
X982 sky130_hd_ro37_nand_0.sky130_hd_inv_1_30.Y sky130_hd_ro37_nand_0.sky130_hd_inv_1_31.Y VDPWR VDPWR sky130_fd_pr__pfet_01v8 ad=0.135 pd=1.27 as=0.26 ps=2.52 w=1 l=0.15
X983 sky130_hd_ro53_nand_0.sky130_hd_inv_1_48.Y sky130_hd_ro53_nand_0.sky130_hd_inv_1_49.Y VDPWR VDPWR sky130_fd_pr__pfet_01v8 ad=0.135 pd=1.27 as=0.26 ps=2.52 w=1 l=0.15
X984 a_28123_2801# a_27631_2762# uo_out[7] uo_out[7] sky130_fd_pr__nfet_01v8 ad=0.066 pd=0.745 as=0.109 ps=1.36 w=0.42 l=0.15
X985 uo_out[7] sky130_hd_ro32_nand_0.sky130_hd_inv_1_26.Y sky130_hd_ro32_nand_0.sky130_hd_inv_1_25.Y uo_out[7] sky130_fd_pr__nfet_01v8 ad=0.169 pd=1.82 as=0.0878 ps=0.92 w=0.65 l=0.15
X986 uo_out[7] sky130_hd_ro37_nand_0.sky130_hd_inv_1_26.Y sky130_hd_ro37_nand_0.sky130_hd_inv_1_25.A uo_out[7] sky130_fd_pr__nfet_01v8 ad=0.169 pd=1.82 as=0.0878 ps=0.92 w=0.65 l=0.15
X987 a_27999_3091# a_27831_3345# uo_out[7] uo_out[7] sky130_fd_pr__nfet_01v8 ad=0.0989 pd=0.995 as=0.121 ps=1.09 w=0.64 l=0.15
X988 VDPWR a_28395_3800# a_28324_3901# VDPWR sky130_fd_pr__pfet_01v8_hvt ad=0.179 pd=1.26 as=0.109 ps=1.08 w=0.75 l=0.15
X989 VDPWR sky130_hd_xor_block_0.sky130_hd_xor2_1_0.A a_24950_30833# VDPWR sky130_fd_pr__pfet_01v8 ad=0.135 pd=1.27 as=0.135 ps=1.27 w=1 l=0.15
X990 VDPWR a_27631_1674# ua[1] VDPWR sky130_fd_pr__pfet_01v8_hvt ad=0.135 pd=1.27 as=0.26 ps=2.52 w=1 l=0.15
X991 a_21429_33018# sky130_hd_xor_block_2.sky130_hd_xor2_1_0.A uo_out[7] uo_out[7] sky130_fd_pr__nfet_01v8 ad=0.0878 pd=0.92 as=0.0878 ps=0.92 w=0.65 l=0.15
X992 VDPWR sky130_hd_ro41_nand_0.sky130_hd_inv_1_12.Y sky130_hd_ro41_nand_0.sky130_hd_inv_1_1.A VDPWR sky130_fd_pr__pfet_01v8 ad=0.26 pd=2.52 as=0.135 ps=1.27 w=1 l=0.15
X993 VDPWR sky130_hd_ro53_nand_0.sky130_hd_inv_1_34.Y sky130_hd_ro53_nand_0.sky130_hd_inv_1_33.Y VDPWR sky130_fd_pr__pfet_01v8 ad=0.26 pd=2.52 as=0.135 ps=1.27 w=1 l=0.15
X994 sky130_hd_ro32_nand_0.sky130_hd_inv_1_3.Y sky130_hd_ro32_nand_0.sky130_hd_inv_1_4.Y uo_out[7] uo_out[7] sky130_fd_pr__nfet_01v8 ad=0.0878 pd=0.92 as=0.169 ps=1.82 w=0.65 l=0.15
X995 VDPWR sky130_hd_xor_block_0.sky130_hd_inv_1_1.Y sky130_hd_xor_block_0.sky130_hd_xor2_1_0.A VDPWR sky130_fd_pr__pfet_01v8 ad=0.26 pd=2.52 as=0.135 ps=1.27 w=1 l=0.15
X996 uo_out[7] sky130_hd_ro41_nand_0.sky130_hd_inv_1_12.Y sky130_hd_ro41_nand_0.sky130_hd_inv_1_1.A uo_out[7] sky130_fd_pr__nfet_01v8 ad=0.169 pd=1.82 as=0.0878 ps=0.92 w=0.65 l=0.15
X997 uo_out[7] sky130_hd_ro47_nand_0.sky130_hd_nand2_1_0.Y sky130_hd_ro47_nand_0.sky130_hd_inv_1_45.Y uo_out[7] sky130_fd_pr__nfet_01v8 ad=0.169 pd=1.82 as=0.0878 ps=0.92 w=0.65 l=0.15
X998 uo_out[7] sky130_hd_ro47_nand_0.sky130_hd_inv_1_27.Y sky130_hd_ro47_nand_0.sky130_hd_inv_1_26.Y uo_out[7] sky130_fd_pr__nfet_01v8 ad=0.169 pd=1.82 as=0.0878 ps=0.92 w=0.65 l=0.15
X999 sky130_hd_ro33_nand_0.sky130_hd_inv_1_18.Y sky130_hd_ro33_nand_0.sky130_hd_inv_1_19.Y VDPWR VDPWR sky130_fd_pr__pfet_01v8 ad=0.135 pd=1.27 as=0.26 ps=2.52 w=1 l=0.15
X1000 a_28188_2653# sky130_hd_div_by_2_3.Q VDPWR VDPWR sky130_fd_pr__pfet_01v8_hvt ad=0.166 pd=1.8 as=0.0864 ps=0.91 w=0.64 l=0.15
X1001 sky130_hd_ro32_nand_0.sky130_hd_inv_1_10.Y sky130_hd_ro32_nand_0.sky130_hd_inv_1_11.Y VDPWR VDPWR sky130_fd_pr__pfet_01v8 ad=0.135 pd=1.27 as=0.26 ps=2.52 w=1 l=0.15
X1002 uo_out[7] sky130_hd_ro33_nand_0.sky130_hd_inv_1_21.Y sky130_hd_ro33_nand_0.sky130_hd_inv_1_20.Y uo_out[7] sky130_fd_pr__nfet_01v8 ad=0.169 pd=1.82 as=0.0878 ps=0.92 w=0.65 l=0.15
X1003 sky130_hd_ro37_nand_0.sky130_hd_inv_1_35.Y sky130_hd_ro37_nand_0.sky130_hd_nand2_1_0.Y VDPWR VDPWR sky130_fd_pr__pfet_01v8 ad=0.135 pd=1.27 as=0.26 ps=2.52 w=1 l=0.15
X1004 sky130_hd_ro47_nand_0.sky130_hd_inv_1_25.Y sky130_hd_ro47_nand_0.sky130_hd_inv_1_26.Y VDPWR VDPWR sky130_fd_pr__pfet_01v8 ad=0.135 pd=1.27 as=0.26 ps=2.52 w=1 l=0.15
X1005 a_28382_2979# a_27392_2979# a_28256_3345# uo_out[7] sky130_fd_pr__special_nfet_01v8 ad=0.066 pd=0.745 as=0.0684 ps=0.74 w=0.36 l=0.15
X1006 uo_out[7] sky130_hd_ro53_nand_0.sky130_hd_inv_1_4.Y sky130_hd_ro53_nand_0.sky130_hd_inv_1_3.Y uo_out[7] sky130_fd_pr__nfet_01v8 ad=0.169 pd=1.82 as=0.0878 ps=0.92 w=0.65 l=0.15
X1007 VDPWR sky130_hd_ro47_nand_0.sky130_hd_inv_1_5.Y sky130_hd_ro47_nand_0.sky130_hd_inv_1_4.Y VDPWR sky130_fd_pr__pfet_01v8 ad=0.26 pd=2.52 as=0.135 ps=1.27 w=1 l=0.15
X1008 a_27631_3850# a_27903_3755# uo_out[7] uo_out[7] sky130_fd_pr__nfet_01v8 ad=0.169 pd=1.82 as=0.0878 ps=0.92 w=0.65 l=0.15
X1009 sky130_hd_ro41_nand_0.sky130_hd_inv_1_6.A sky130_hd_ro41_nand_0.sky130_hd_inv_1_5.A VDPWR VDPWR sky130_fd_pr__pfet_01v8 ad=0.135 pd=1.27 as=0.26 ps=2.52 w=1 l=0.15
X1010 sky130_hd_ro41_nand_0.sky130_hd_inv_1_6.A sky130_hd_ro41_nand_0.sky130_hd_inv_1_5.A uo_out[7] uo_out[7] sky130_fd_pr__nfet_01v8 ad=0.0878 pd=0.92 as=0.169 ps=1.82 w=0.65 l=0.15
X1011 a_27999_2003# a_27831_2257# uo_out[7] uo_out[7] sky130_fd_pr__nfet_01v8 ad=0.0989 pd=0.995 as=0.121 ps=1.09 w=0.64 l=0.15
X1012 ua[0] sky130_hd_ro32_nand_0.sky130_hd_inv_1_1.Y uo_out[7] uo_out[7] sky130_fd_pr__nfet_01v8 ad=0.0878 pd=0.92 as=0.169 ps=1.82 w=0.65 l=0.15
X1013 sky130_hd_ro33_nand_0.sky130_hd_inv_1_22.Y sky130_hd_ro33_nand_0.sky130_hd_inv_1_23.Y VDPWR VDPWR sky130_fd_pr__pfet_01v8 ad=0.135 pd=1.27 as=0.26 ps=2.52 w=1 l=0.15
X1014 sky130_hd_ro53_nand_0.sky130_hd_inv_1_41.A sky130_hd_ro53_nand_0.sky130_hd_inv_1_42.Y VDPWR VDPWR sky130_fd_pr__pfet_01v8 ad=0.135 pd=1.27 as=0.26 ps=2.52 w=1 l=0.15
X1015 sky130_hd_ro32_nand_0.sky130_hd_inv_1_7.Y sky130_hd_ro32_nand_0.sky130_hd_inv_1_8.Y VDPWR VDPWR sky130_fd_pr__pfet_01v8 ad=0.135 pd=1.27 as=0.26 ps=2.52 w=1 l=0.15
X1016 uo_out[7] a_22058_35537# a_22065_35837# uo_out[7] sky130_fd_pr__nfet_01v8 ad=0.0567 pd=0.69 as=0.109 ps=1.36 w=0.42 l=0.15
X1017 uo_out[7] sky130_hd_ro33_nand_0.sky130_hd_inv_1_25.Y sky130_hd_ro33_nand_0.sky130_hd_inv_1_24.Y uo_out[7] sky130_fd_pr__nfet_01v8 ad=0.169 pd=1.82 as=0.0878 ps=0.92 w=0.65 l=0.15
X1018 uo_out[7] sky130_hd_ro53_nand_0.sky130_hd_inv_1_8.Y sky130_hd_ro53_nand_0.sky130_hd_inv_1_7.Y uo_out[7] sky130_fd_pr__nfet_01v8 ad=0.169 pd=1.82 as=0.0878 ps=0.92 w=0.65 l=0.15
X1019 VDPWR sky130_hd_ro37_nand_0.sky130_hd_inv_1_3.A sky130_hd_ro37_nand_0.sky130_hd_inv_1_4.A VDPWR sky130_fd_pr__pfet_01v8 ad=0.26 pd=2.52 as=0.135 ps=1.27 w=1 l=0.15
X1020 sky130_hd_ro41_nand_0.sky130_hd_inv_1_2.A sky130_hd_ro41_nand_0.sky130_hd_inv_1_1.A VDPWR VDPWR sky130_fd_pr__pfet_01v8 ad=0.135 pd=1.27 as=0.26 ps=2.52 w=1 l=0.15
X1021 sky130_hd_ro53_nand_0.sky130_hd_inv_1_44.Y sky130_hd_ro53_nand_0.sky130_hd_inv_1_45.Y uo_out[7] uo_out[7] sky130_fd_pr__nfet_01v8 ad=0.0878 pd=0.92 as=0.169 ps=1.82 w=0.65 l=0.15
X1022 sky130_hd_ro41_nand_0.sky130_hd_inv_1_2.A sky130_hd_ro41_nand_0.sky130_hd_inv_1_1.A uo_out[7] uo_out[7] sky130_fd_pr__nfet_01v8 ad=0.0878 pd=0.92 as=0.169 ps=1.82 w=0.65 l=0.15
X1023 uo_out[7] sky130_hd_ro47_nand_0.sky130_hd_inv_1_19.Y sky130_hd_ro47_nand_0.sky130_hd_inv_1_18.Y uo_out[7] sky130_fd_pr__nfet_01v8 ad=0.169 pd=1.82 as=0.0878 ps=0.92 w=0.65 l=0.15
X1024 VDPWR a_24123_35537# a_24130_35837# VDPWR sky130_fd_pr__pfet_01v8_hvt ad=0.0864 pd=0.91 as=0.166 ps=1.8 w=0.64 l=0.15
X1025 sky130_hd_ro37_nand_0.sky130_hd_inv_1_28.Y sky130_hd_ro37_nand_0.sky130_hd_inv_1_29.Y uo_out[7] uo_out[7] sky130_fd_pr__nfet_01v8 ad=0.0878 pd=0.92 as=0.169 ps=1.82 w=0.65 l=0.15
X1026 sky130_hd_ro53_nand_0.sky130_hd_inv_1_45.Y sky130_hd_ro53_nand_0.sky130_hd_inv_1_46.Y VDPWR VDPWR sky130_fd_pr__pfet_01v8 ad=0.135 pd=1.27 as=0.26 ps=2.52 w=1 l=0.15
X1027 a_28382_1891# a_27392_1891# a_28256_2257# uo_out[7] sky130_fd_pr__special_nfet_01v8 ad=0.066 pd=0.745 as=0.0684 ps=0.74 w=0.36 l=0.15
X1028 sky130_hd_ro32_nand_0.sky130_hd_inv_1_4.Y sky130_hd_ro32_nand_0.sky130_hd_inv_1_5.Y VDPWR VDPWR sky130_fd_pr__pfet_01v8 ad=0.135 pd=1.27 as=0.26 ps=2.52 w=1 l=0.15
X1029 sky130_hd_ro47_nand_0.sky130_hd_inv_1_11.A sky130_hd_ro47_nand_0.sky130_hd_inv_1_10.A uo_out[7] uo_out[7] sky130_fd_pr__nfet_01v8 ad=0.0878 pd=0.92 as=0.169 ps=1.82 w=0.65 l=0.15
X1030 a_28395_1624# a_28188_1565# a_28571_1347# VDPWR sky130_fd_pr__pfet_01v8_hvt ad=0.0683 pd=0.745 as=0.0767 ps=0.785 w=0.42 l=0.15
X1031 uo_out[7] sky130_hd_ro53_nand_0.sky130_hd_inv_1_22.A sky130_hd_ro53_nand_0.sky130_hd_inv_1_22.Y uo_out[7] sky130_fd_pr__nfet_01v8 ad=0.169 pd=1.82 as=0.0878 ps=0.92 w=0.65 l=0.15
X1032 uo_out[7] sky130_hd_ro47_nand_0.sky130_hd_inv_1_24.Y sky130_hd_ro47_nand_0.sky130_hd_inv_1_23.Y uo_out[7] sky130_fd_pr__nfet_01v8 ad=0.169 pd=1.82 as=0.0878 ps=0.92 w=0.65 l=0.15
X1033 sky130_hd_ro53_nand_0.sky130_hd_inv_1_49.Y sky130_hd_ro53_nand_0.sky130_hd_inv_1_50.Y uo_out[7] uo_out[7] sky130_fd_pr__nfet_01v8 ad=0.0878 pd=0.92 as=0.169 ps=1.82 w=0.65 l=0.15
X1034 sky130_hd_xor_block_2.sky130_hd_inv_1_3.A sky130_hd_xor_block_3.XOROUT uo_out[7] uo_out[7] sky130_fd_pr__nfet_01v8 ad=0.0878 pd=0.92 as=0.169 ps=1.82 w=0.65 l=0.15
X1035 VDPWR sky130_hd_ro53_nand_0.sky130_hd_inv_1_21.A sky130_hd_ro53_nand_0.sky130_hd_inv_1_22.A VDPWR sky130_fd_pr__pfet_01v8 ad=0.26 pd=2.52 as=0.135 ps=1.27 w=1 l=0.15
X1036 uo_out[7] a_27536_2409# sky130_hd_div_by_2_2.Qb uo_out[7] sky130_fd_pr__nfet_01v8 ad=0.097 pd=0.975 as=0.169 ps=1.82 w=0.65 l=0.15
X1037 sky130_hd_ro41_nand_0.sky130_hd_inv_1_28.Y sky130_hd_ro41_nand_0.sky130_hd_inv_1_29.Y VDPWR VDPWR sky130_fd_pr__pfet_01v8 ad=0.135 pd=1.27 as=0.26 ps=2.52 w=1 l=0.15
X1038 sky130_hd_ro41_nand_0.sky130_hd_inv_1_28.Y sky130_hd_ro41_nand_0.sky130_hd_inv_1_29.Y uo_out[7] uo_out[7] sky130_fd_pr__nfet_01v8 ad=0.0878 pd=0.92 as=0.169 ps=1.82 w=0.65 l=0.15
X1039 sky130_hd_ro53_nand_0.sky130_hd_inv_1_50.Y sky130_hd_ro53_nand_0.sky130_hd_inv_1_51.Y VDPWR VDPWR sky130_fd_pr__pfet_01v8 ad=0.135 pd=1.27 as=0.26 ps=2.52 w=1 l=0.15
X1040 uo_out[7] sky130_hd_ro33_nand_0.sky130_hd_inv_1_18.Y sky130_hd_ro33_nand_0.sky130_hd_inv_1_17.Y uo_out[7] sky130_fd_pr__nfet_01v8 ad=0.169 pd=1.82 as=0.0878 ps=0.92 w=0.65 l=0.15
X1041 uo_out[7] sky130_hd_xor_block_3.sky130_hd_xor2_1_0.A a_19445_33932# uo_out[7] sky130_fd_pr__nfet_01v8 ad=0.0878 pd=0.92 as=0.0878 ps=0.92 w=0.65 l=0.15
X1042 VDPWR sky130_hd_ro47_nand_0.sky130_hd_inv_1_2.Y sky130_hd_ro47_nand_0.sky130_hd_inv_1_1.Y VDPWR sky130_fd_pr__pfet_01v8 ad=0.26 pd=2.52 as=0.135 ps=1.27 w=1 l=0.15
X1043 sky130_hd_ro41_nand_0.sky130_hd_inv_1_9.A sky130_hd_ro41_nand_0.sky130_hd_inv_1_8.A VDPWR VDPWR sky130_fd_pr__pfet_01v8 ad=0.135 pd=1.27 as=0.26 ps=2.52 w=1 l=0.15
X1044 uo_out[7] sky130_hd_ro47_nand_0.sky130_hd_inv_1_28.Y sky130_hd_ro47_nand_0.sky130_hd_inv_1_27.Y uo_out[7] sky130_fd_pr__nfet_01v8 ad=0.169 pd=1.82 as=0.0878 ps=0.92 w=0.65 l=0.15
X1045 a_28571_1347# a_28324_1725# VDPWR VDPWR sky130_fd_pr__pfet_01v8_hvt ad=0.0767 pd=0.785 as=0.179 ps=1.26 w=0.42 l=0.15
X1046 sky130_hd_ro41_nand_0.sky130_hd_inv_1_9.A sky130_hd_ro41_nand_0.sky130_hd_inv_1_8.A uo_out[7] uo_out[7] sky130_fd_pr__nfet_01v8 ad=0.0878 pd=0.92 as=0.169 ps=1.82 w=0.65 l=0.15
X1047 VDPWR sky130_hd_ro53_nand_0.sky130_hd_inv_1_44.Y sky130_hd_ro53_nand_0.sky130_hd_inv_1_43.Y VDPWR sky130_fd_pr__pfet_01v8 ad=0.26 pd=2.52 as=0.135 ps=1.27 w=1 l=0.15
X1048 sky130_hd_ro33_nand_0.sky130_hd_inv_1_2.Y sky130_hd_ro33_nand_0.sky130_hd_inv_1_3.Y VDPWR VDPWR sky130_fd_pr__pfet_01v8 ad=0.135 pd=1.27 as=0.26 ps=2.52 w=1 l=0.15
X1049 VDPWR sky130_hd_ro41_nand_0.sky130_hd_inv_1_13.Y sky130_hd_ro41_nand_0.sky130_hd_inv_1_12.Y VDPWR sky130_fd_pr__pfet_01v8 ad=0.26 pd=2.52 as=0.135 ps=1.27 w=1 l=0.15
X1050 sky130_hd_ro47_nand_0.sky130_hd_inv_1_21.Y sky130_hd_ro47_nand_0.sky130_hd_inv_1_22.Y uo_out[7] uo_out[7] sky130_fd_pr__nfet_01v8 ad=0.0878 pd=0.92 as=0.169 ps=1.82 w=0.65 l=0.15
X1051 sky130_hd_ro33_nand_0.sky130_hd_inv_1_28.Y sky130_hd_ro33_nand_0.sky130_hd_inv_1_29.Y uo_out[7] uo_out[7] sky130_fd_pr__nfet_01v8 ad=0.0878 pd=0.92 as=0.169 ps=1.82 w=0.65 l=0.15
X1052 uo_out[7] sky130_hd_ro41_nand_0.sky130_hd_inv_1_13.Y sky130_hd_ro41_nand_0.sky130_hd_inv_1_12.Y uo_out[7] sky130_fd_pr__nfet_01v8 ad=0.169 pd=1.82 as=0.0878 ps=0.92 w=0.65 l=0.15
X1053 uo_out[7] sky130_hd_ro47_nand_0.sky130_hd_inv_1_1.Y sky130_hd_xor_block_1.XORB uo_out[7] sky130_fd_pr__nfet_01v8 ad=0.169 pd=1.82 as=0.0878 ps=0.92 w=0.65 l=0.15
X1054 VDPWR sky130_hd_ro53_nand_0.sky130_hd_inv_1_16.A sky130_hd_ro53_nand_0.sky130_hd_inv_1_17.A VDPWR sky130_fd_pr__pfet_01v8 ad=0.26 pd=2.52 as=0.135 ps=1.27 w=1 l=0.15
X1055 VDPWR sky130_hd_ro37_nand_0.sky130_hd_inv_1_6.A sky130_hd_xor_block_3.XORB VDPWR sky130_fd_pr__pfet_01v8 ad=0.26 pd=2.52 as=0.135 ps=1.27 w=1 l=0.15
X1056 VDPWR sky130_hd_ro47_nand_0.sky130_hd_inv_1_36.Y sky130_hd_ro47_nand_0.sky130_hd_inv_1_35.A VDPWR sky130_fd_pr__pfet_01v8 ad=0.26 pd=2.52 as=0.135 ps=1.27 w=1 l=0.15
X1057 uo_out[7] sky130_hd_ro37_nand_0.sky130_hd_inv_1_16.Y sky130_hd_ro37_nand_0.sky130_hd_inv_1_15.Y uo_out[7] sky130_fd_pr__nfet_01v8 ad=0.169 pd=1.82 as=0.0878 ps=0.92 w=0.65 l=0.15
X1058 a_28395_1624# a_28195_1469# a_28544_1713# uo_out[7] sky130_fd_pr__special_nfet_01v8 ad=0.0621 pd=0.705 as=0.0696 ps=0.765 w=0.36 l=0.15
X1059 uo_out[7] sky130_hd_ro32_nand_0.sky130_hd_inv_1_12.Y sky130_hd_ro32_nand_0.sky130_hd_inv_1_11.Y uo_out[7] sky130_fd_pr__nfet_01v8 ad=0.169 pd=1.82 as=0.0878 ps=0.92 w=0.65 l=0.15
X1060 sky130_hd_xor_block_0.sky130_hd_inv_1_1.Y sky130_hd_xor_block_0.XORB uo_out[7] uo_out[7] sky130_fd_pr__nfet_01v8 ad=0.0878 pd=0.92 as=0.169 ps=1.82 w=0.65 l=0.15
X1061 sky130_hd_ro32_nand_0.sky130_hd_inv_1_28.Y sky130_hd_ro32_nand_0.sky130_hd_inv_1_29.Y VDPWR VDPWR sky130_fd_pr__pfet_01v8 ad=0.135 pd=1.27 as=0.26 ps=2.52 w=1 l=0.15
X1062 a_28256_2257# a_27392_1891# a_27999_2003# VDPWR sky130_fd_pr__pfet_01v8_hvt ad=0.0567 pd=0.69 as=0.109 ps=1.08 w=0.42 l=0.15
X1063 VDPWR sky130_hd_ro37_nand_0.sky130_hd_inv_1_2.A sky130_hd_ro37_nand_0.sky130_hd_inv_1_3.A VDPWR sky130_fd_pr__pfet_01v8 ad=0.26 pd=2.52 as=0.135 ps=1.27 w=1 l=0.15
X1064 sky130_hd_ro33_nand_0.sky130_hd_inv_1_7.Y sky130_hd_ro33_nand_0.sky130_hd_inv_1_8.Y VDPWR VDPWR sky130_fd_pr__pfet_01v8 ad=0.135 pd=1.27 as=0.26 ps=2.52 w=1 l=0.15
X1065 uo_out[7] a_21179_33268# sky130_hd_xor_block_2.XOROUT uo_out[7] sky130_fd_pr__nfet_01v8 ad=0.208 pd=1.94 as=0.25 ps=1.42 w=0.65 l=0.15
X1066 uo_out[7] sky130_hd_ro37_nand_0.sky130_hd_inv_1_20.Y sky130_hd_ro37_nand_0.sky130_hd_inv_1_19.Y uo_out[7] sky130_fd_pr__nfet_01v8 ad=0.169 pd=1.82 as=0.0878 ps=0.92 w=0.65 l=0.15
X1067 sky130_hd_xor_block_0.sky130_hd_xor2_1_0.A sky130_hd_xor_block_0.sky130_hd_inv_1_1.Y VDPWR VDPWR sky130_fd_pr__pfet_01v8 ad=0.135 pd=1.27 as=0.26 ps=2.52 w=1 l=0.15
X1068 sky130_hd_ro47_nand_0.sky130_hd_inv_1_26.Y sky130_hd_ro47_nand_0.sky130_hd_inv_1_27.Y uo_out[7] uo_out[7] sky130_fd_pr__nfet_01v8 ad=0.0878 pd=0.92 as=0.169 ps=1.82 w=0.65 l=0.15
X1069 uo_out[7] sky130_hd_ro53_nand_0.sky130_hd_inv_1_10.Y sky130_hd_ro53_nand_0.sky130_hd_inv_1_9.Y uo_out[7] sky130_fd_pr__nfet_01v8 ad=0.169 pd=1.82 as=0.0878 ps=0.92 w=0.65 l=0.15
X1070 uo_out[7] sky130_hd_ro33_nand_0.sky130_hd_inv_1_27.Y sky130_hd_ro33_nand_0.sky130_hd_inv_1_26.Y uo_out[7] sky130_fd_pr__nfet_01v8 ad=0.169 pd=1.82 as=0.0878 ps=0.92 w=0.65 l=0.15
X1071 uo_out[7] sky130_hd_ro32_nand_0.sky130_hd_inv_1_9.Y sky130_hd_ro32_nand_0.sky130_hd_inv_1_8.Y uo_out[7] sky130_fd_pr__nfet_01v8 ad=0.169 pd=1.82 as=0.0878 ps=0.92 w=0.65 l=0.15
X1072 VDPWR sky130_hd_ro53_nand_0.sky130_hd_inv_1_11.Y sky130_hd_ro53_nand_0.sky130_hd_inv_1_10.Y VDPWR sky130_fd_pr__pfet_01v8 ad=0.26 pd=2.52 as=0.135 ps=1.27 w=1 l=0.15
X1073 a_28742_1725# a_28188_1565# a_28395_1624# uo_out[7] sky130_fd_pr__special_nfet_01v8 ad=0.0813 pd=0.83 as=0.0621 ps=0.705 w=0.36 l=0.15
X1074 VDPWR sky130_hd_ro32_nand_0.sky130_hd_inv_1_16.Y sky130_hd_ro32_nand_0.sky130_hd_inv_1_15.Y VDPWR sky130_fd_pr__pfet_01v8 ad=0.26 pd=2.52 as=0.135 ps=1.27 w=1 l=0.15
X1075 sky130_hd_ro32_nand_0.sky130_hd_inv_1_25.Y sky130_hd_ro32_nand_0.sky130_hd_inv_1_26.Y VDPWR VDPWR sky130_fd_pr__pfet_01v8 ad=0.135 pd=1.27 as=0.26 ps=2.52 w=1 l=0.15
X1076 sky130_hd_ro53_nand_0.sky130_hd_inv_1_3.Y sky130_hd_ro53_nand_0.sky130_hd_inv_1_4.Y uo_out[7] uo_out[7] sky130_fd_pr__nfet_01v8 ad=0.0878 pd=0.92 as=0.169 ps=1.82 w=0.65 l=0.15
X1077 VDPWR sky130_hd_ro33_nand_0.sky130_hd_inv_1_22.Y sky130_hd_ro33_nand_0.sky130_hd_inv_1_21.Y VDPWR sky130_fd_pr__pfet_01v8 ad=0.26 pd=2.52 as=0.135 ps=1.27 w=1 l=0.15
X1078 sky130_hd_ro47_nand_0.sky130_hd_inv_1_4.Y sky130_hd_ro47_nand_0.sky130_hd_inv_1_5.Y VDPWR VDPWR sky130_fd_pr__pfet_01v8 ad=0.135 pd=1.27 as=0.26 ps=2.52 w=1 l=0.15
X1079 sky130_hd_ro41_nand_0.sky130_hd_inv_1_25.Y sky130_hd_ro41_nand_0.sky130_hd_inv_1_26.Y VDPWR VDPWR sky130_fd_pr__pfet_01v8 ad=0.135 pd=1.27 as=0.26 ps=2.52 w=1 l=0.15
X1080 sky130_hd_ro41_nand_0.sky130_hd_inv_1_25.Y sky130_hd_ro41_nand_0.sky130_hd_inv_1_26.Y uo_out[7] uo_out[7] sky130_fd_pr__nfet_01v8 ad=0.0878 pd=0.92 as=0.169 ps=1.82 w=0.65 l=0.15
X1081 VDPWR sky130_hd_ro47_nand_0.sky130_hd_inv_1_45.Y sky130_hd_ro47_nand_0.sky130_hd_inv_1_44.Y VDPWR sky130_fd_pr__pfet_01v8 ad=0.26 pd=2.52 as=0.135 ps=1.27 w=1 l=0.15
X1082 VDPWR sky130_hd_ro37_nand_0.sky130_hd_inv_1_24.Y sky130_hd_ro37_nand_0.sky130_hd_inv_1_23.Y VDPWR sky130_fd_pr__pfet_01v8 ad=0.26 pd=2.52 as=0.135 ps=1.27 w=1 l=0.15
X1083 VDPWR sky130_hd_ro53_nand_0.sky130_hd_inv_1_19.A sky130_hd_ro53_nand_0.sky130_hd_inv_1_20.A VDPWR sky130_fd_pr__pfet_01v8 ad=0.26 pd=2.52 as=0.135 ps=1.27 w=1 l=0.15
X1084 uo_out[7] sky130_hd_ro53_nand_0.sky130_hd_inv_1_29.Y sky130_hd_ro53_nand_0.sky130_hd_inv_1_28.Y uo_out[7] sky130_fd_pr__nfet_01v8 ad=0.169 pd=1.82 as=0.0878 ps=0.92 w=0.65 l=0.15
X1085 VDPWR sky130_hd_ro37_nand_0.sky130_hd_inv_1_27.Y sky130_hd_ro37_nand_0.sky130_hd_inv_1_26.Y VDPWR sky130_fd_pr__pfet_01v8 ad=0.26 pd=2.52 as=0.135 ps=1.27 w=1 l=0.15
X1086 uo_out[7] sky130_hd_ro37_nand_0.sky130_hd_inv_1_13.Y sky130_hd_ro37_nand_0.sky130_hd_inv_1_12.Y uo_out[7] sky130_fd_pr__nfet_01v8 ad=0.169 pd=1.82 as=0.0878 ps=0.92 w=0.65 l=0.15
X1087 VDPWR sky130_hd_ro53_nand_0.sky130_hd_inv_1_30.Y sky130_hd_ro53_nand_0.sky130_hd_inv_1_29.Y VDPWR sky130_fd_pr__pfet_01v8 ad=0.26 pd=2.52 as=0.135 ps=1.27 w=1 l=0.15
X1088 VDPWR a_28424_2159# a_28340_2257# VDPWR sky130_fd_pr__pfet_01v8_hvt ad=0.111 pd=1.37 as=0.0882 ps=0.84 w=0.42 l=0.15
X1089 VDPWR sky130_hd_ro41_nand_0.sky130_hd_inv_1_30.Y sky130_hd_ro41_nand_0.sky130_hd_inv_1_29.A VDPWR sky130_fd_pr__pfet_01v8 ad=0.26 pd=2.52 as=0.135 ps=1.27 w=1 l=0.15
X1090 uo_out[7] sky130_hd_ro41_nand_0.sky130_hd_inv_1_30.Y sky130_hd_ro41_nand_0.sky130_hd_inv_1_29.A uo_out[7] sky130_fd_pr__nfet_01v8 ad=0.169 pd=1.82 as=0.0878 ps=0.92 w=0.65 l=0.15
X1091 uo_out[7] sky130_hd_ro47_nand_0.sky130_hd_inv_1_33.Y sky130_hd_ro47_nand_0.sky130_hd_inv_1_32.Y uo_out[7] sky130_fd_pr__nfet_01v8 ad=0.169 pd=1.82 as=0.0878 ps=0.92 w=0.65 l=0.15
X1092 uo_out[7] sky130_hd_xor_block_1.sky130_hd_xor2_1_0.A a_22936_31990# uo_out[7] sky130_fd_pr__nfet_01v8 ad=0.0878 pd=0.92 as=0.0878 ps=0.92 w=0.65 l=0.15
X1093 uo_out[7] sky130_hd_xor_block_0.sky130_hd_inv_1_3.A sky130_hd_xor_block_0.sky130_hd_xor2_1_0.B uo_out[7] sky130_fd_pr__nfet_01v8 ad=0.169 pd=1.82 as=0.0878 ps=0.92 w=0.65 l=0.15
X1094 sky130_hd_ro47_nand_0.sky130_hd_inv_1_23.Y sky130_hd_ro47_nand_0.sky130_hd_inv_1_24.Y uo_out[7] uo_out[7] sky130_fd_pr__nfet_01v8 ad=0.0878 pd=0.92 as=0.169 ps=1.82 w=0.65 l=0.15
X1095 a_21774_35537# a_22065_35837# a_22016_35929# VDPWR sky130_fd_pr__pfet_01v8_hvt ad=0.0567 pd=0.69 as=0.0882 ps=0.84 w=0.42 l=0.15
X1096 uo_out[7] sky130_hd_xor_block_1.XORB sky130_hd_xor_block_1.sky130_hd_inv_1_1.Y uo_out[7] sky130_fd_pr__nfet_01v8 ad=0.169 pd=1.82 as=0.0878 ps=0.92 w=0.65 l=0.15
X1097 sky130_hd_ro53_nand_0.sky130_hd_inv_1_40.Y sky130_hd_ro53_nand_0.sky130_hd_inv_1_41.Y VDPWR VDPWR sky130_fd_pr__pfet_01v8 ad=0.135 pd=1.27 as=0.26 ps=2.52 w=1 l=0.15
X1098 uo_out[7] sky130_hd_ro53_nand_0.sky130_hd_inv_1_7.Y sky130_hd_ro53_nand_0.sky130_hd_inv_1_6.Y uo_out[7] sky130_fd_pr__nfet_01v8 ad=0.169 pd=1.82 as=0.0878 ps=0.92 w=0.65 l=0.15
X1099 a_23839_35537# a_24130_35837# a_24081_35929# VDPWR sky130_fd_pr__pfet_01v8_hvt ad=0.0567 pd=0.69 as=0.0882 ps=0.84 w=0.42 l=0.15
X1100 VDPWR sky130_hd_xor_block_3.sky130_hd_inv_1_3.A sky130_hd_xor_block_3.sky130_hd_xor2_1_0.B VDPWR sky130_fd_pr__pfet_01v8 ad=0.26 pd=2.52 as=0.135 ps=1.27 w=1 l=0.15
X1101 VDPWR sky130_hd_xor_block_1.XOROUT sky130_hd_xor_block_0.sky130_hd_inv_1_3.A VDPWR sky130_fd_pr__pfet_01v8 ad=0.26 pd=2.52 as=0.135 ps=1.27 w=1 l=0.15
X1102 a_28742_2813# a_28195_2557# a_28395_2712# VDPWR sky130_fd_pr__pfet_01v8_hvt ad=0.0578 pd=0.695 as=0.0683 ps=0.745 w=0.42 l=0.15
X1103 sky130_hd_ro33_nand_0.sky130_hd_inv_1_17.Y sky130_hd_ro33_nand_0.sky130_hd_inv_1_18.Y uo_out[7] uo_out[7] sky130_fd_pr__nfet_01v8 ad=0.0878 pd=0.92 as=0.169 ps=1.82 w=0.65 l=0.15
X1104 a_19445_33932# sky130_hd_xor_block_3.sky130_hd_xor2_1_0.B uo_out[7] uo_out[7] sky130_fd_pr__nfet_01v8 ad=0.0878 pd=0.92 as=0.169 ps=1.82 w=0.65 l=0.15
X1105 sky130_hd_ro47_nand_0.sky130_hd_inv_1_1.Y sky130_hd_ro47_nand_0.sky130_hd_inv_1_2.Y VDPWR VDPWR sky130_fd_pr__pfet_01v8 ad=0.135 pd=1.27 as=0.26 ps=2.52 w=1 l=0.15
X1106 sky130_hd_xor_block_3.sky130_hd_inv_1_1.Y sky130_hd_xor_block_3.XORB uo_out[7] uo_out[7] sky130_fd_pr__nfet_01v8 ad=0.0878 pd=0.92 as=0.169 ps=1.82 w=0.65 l=0.15
X1107 uo_out[7] sky130_hd_ro32_nand_0.sky130_hd_nand2_1_0.Y sky130_hd_ro32_nand_0.sky130_hd_inv_1_31.Y uo_out[7] sky130_fd_pr__nfet_01v8 ad=0.169 pd=1.82 as=0.0878 ps=0.92 w=0.65 l=0.15
X1108 sky130_hd_ro53_nand_0.sky130_hd_inv_1_43.Y sky130_hd_ro53_nand_0.sky130_hd_inv_1_44.Y VDPWR VDPWR sky130_fd_pr__pfet_01v8 ad=0.135 pd=1.27 as=0.26 ps=2.52 w=1 l=0.15
X1109 uo_out[7] sky130_hd_ro32_nand_0.sky130_hd_inv_1_30.Y sky130_hd_ro32_nand_0.sky130_hd_inv_1_29.Y uo_out[7] sky130_fd_pr__nfet_01v8 ad=0.169 pd=1.82 as=0.0878 ps=0.92 w=0.65 l=0.15
X1110 sky130_hd_xor_block_2.sky130_hd_inv_1_1.Y sky130_hd_xor_block_2.XORB uo_out[7] uo_out[7] sky130_fd_pr__nfet_01v8 ad=0.0878 pd=0.92 as=0.169 ps=1.82 w=0.65 l=0.15
X1111 uo_out[7] sky130_hd_ro37_nand_0.sky130_hd_inv_1_22.Y sky130_hd_ro37_nand_0.sky130_hd_inv_1_21.Y uo_out[7] sky130_fd_pr__nfet_01v8 ad=0.169 pd=1.82 as=0.0878 ps=0.92 w=0.65 l=0.15
X1112 VDPWR sky130_hd_ro47_nand_0.sky130_hd_inv_1_42.Y sky130_hd_ro47_nand_0.sky130_hd_inv_1_41.Y VDPWR sky130_fd_pr__pfet_01v8 ad=0.26 pd=2.52 as=0.135 ps=1.27 w=1 l=0.15
X1113 sky130_hd_ro33_nand_0.sky130_hd_inv_1_29.Y sky130_hd_ro33_nand_0.sky130_hd_inv_1_30.Y VDPWR VDPWR sky130_fd_pr__pfet_01v8 ad=0.135 pd=1.27 as=0.26 ps=2.52 w=1 l=0.15
X1114 VDPWR sky130_hd_ro37_nand_0.sky130_hd_inv_1_21.Y sky130_hd_ro37_nand_0.sky130_hd_inv_1_20.Y VDPWR sky130_fd_pr__pfet_01v8 ad=0.26 pd=2.52 as=0.135 ps=1.27 w=1 l=0.15
X1115 sky130_hd_xor_block_3.XORB sky130_hd_ro37_nand_0.sky130_hd_inv_1_6.A VDPWR VDPWR sky130_fd_pr__pfet_01v8 ad=0.135 pd=1.27 as=0.26 ps=2.52 w=1 l=0.15
X1116 sky130_hd_ro47_nand_0.sky130_hd_inv_1_8.A sky130_hd_ro47_nand_0.sky130_hd_inv_1_7.A VDPWR VDPWR sky130_fd_pr__pfet_01v8 ad=0.135 pd=1.27 as=0.26 ps=2.52 w=1 l=0.15
X1117 uo_out[7] sky130_hd_ro53_nand_0.sky130_hd_inv_1_33.Y sky130_hd_ro53_nand_0.sky130_hd_inv_1_32.Y uo_out[7] sky130_fd_pr__nfet_01v8 ad=0.169 pd=1.82 as=0.0878 ps=0.92 w=0.65 l=0.15
X1118 uo_out[7] sky130_hd_ro33_nand_0.sky130_hd_inv_1_12.Y sky130_hd_ro33_nand_0.sky130_hd_inv_1_11.Y uo_out[7] sky130_fd_pr__nfet_01v8 ad=0.169 pd=1.82 as=0.0878 ps=0.92 w=0.65 l=0.15
X1119 sky130_hd_xor_block_2.sky130_hd_xor2_1_0.A sky130_hd_xor_block_2.sky130_hd_inv_1_1.Y VDPWR VDPWR sky130_fd_pr__pfet_01v8 ad=0.135 pd=1.27 as=0.26 ps=2.52 w=1 l=0.15
X1120 VDPWR sky130_hd_ro41_nand_0.sky130_hd_inv_1_36.Y sky130_hd_ro41_nand_0.sky130_hd_inv_1_35.Y VDPWR sky130_fd_pr__pfet_01v8 ad=0.26 pd=2.52 as=0.135 ps=1.27 w=1 l=0.15
X1121 uo_out[7] sky130_hd_ro47_nand_0.sky130_hd_inv_1_41.Y sky130_hd_ro47_nand_0.sky130_hd_inv_1_40.Y uo_out[7] sky130_fd_pr__nfet_01v8 ad=0.169 pd=1.82 as=0.0878 ps=0.92 w=0.65 l=0.15
X1122 uo_out[7] sky130_hd_ro32_nand_0.sky130_hd_inv_1_27.Y sky130_hd_ro32_nand_0.sky130_hd_inv_1_26.Y uo_out[7] sky130_fd_pr__nfet_01v8 ad=0.169 pd=1.82 as=0.0878 ps=0.92 w=0.65 l=0.15
X1123 sky130_hd_ro41_nand_0.sky130_hd_inv_1_27.Y sky130_hd_ro41_nand_0.sky130_hd_inv_1_28.Y VDPWR VDPWR sky130_fd_pr__pfet_01v8 ad=0.135 pd=1.27 as=0.26 ps=2.52 w=1 l=0.15
X1124 uo_out[7] sky130_hd_ro41_nand_0.sky130_hd_inv_1_36.Y sky130_hd_ro41_nand_0.sky130_hd_inv_1_35.Y uo_out[7] sky130_fd_pr__nfet_01v8 ad=0.169 pd=1.82 as=0.0878 ps=0.92 w=0.65 l=0.15
X1125 VDPWR sky130_hd_div_by_2_2.Q a_27392_1891# VDPWR sky130_fd_pr__pfet_01v8_hvt ad=0.0864 pd=0.91 as=0.166 ps=1.8 w=0.64 l=0.15
X1126 a_22265_35537# a_22065_35837# a_22414_35563# uo_out[7] sky130_fd_pr__special_nfet_01v8 ad=0.0621 pd=0.705 as=0.0696 ps=0.765 w=0.36 l=0.15
X1127 uo_out[7] sky130_hd_ro33_nand_0.sky130_hd_inv_1_16.Y sky130_hd_ro33_nand_0.sky130_hd_inv_1_15.Y uo_out[7] sky130_fd_pr__nfet_01v8 ad=0.169 pd=1.82 as=0.0878 ps=0.92 w=0.65 l=0.15
X1128 uo_out[7] sky130_hd_ro37_nand_0.sky130_hd_inv_1_10.Y sky130_hd_ro37_nand_0.sky130_hd_inv_1_9.Y uo_out[7] sky130_fd_pr__nfet_01v8 ad=0.169 pd=1.82 as=0.0878 ps=0.92 w=0.65 l=0.15
X1129 sky130_hd_ro41_nand_0.sky130_hd_inv_1_27.Y sky130_hd_ro41_nand_0.sky130_hd_inv_1_28.Y uo_out[7] uo_out[7] sky130_fd_pr__nfet_01v8 ad=0.0878 pd=0.92 as=0.169 ps=1.82 w=0.65 l=0.15
X1130 sky130_hd_ro47_nand_0.sky130_hd_inv_1_20.Y sky130_hd_ro47_nand_0.sky130_hd_inv_1_21.Y VDPWR VDPWR sky130_fd_pr__pfet_01v8 ad=0.135 pd=1.27 as=0.26 ps=2.52 w=1 l=0.15
X1131 sky130_hd_ro53_nand_0.sky130_hd_inv_1_9.Y sky130_hd_ro53_nand_0.sky130_hd_inv_1_10.Y uo_out[7] uo_out[7] sky130_fd_pr__nfet_01v8 ad=0.0878 pd=0.92 as=0.169 ps=1.82 w=0.65 l=0.15
X1132 sky130_hd_ro33_nand_0.sky130_hd_inv_1_10.Y sky130_hd_ro33_nand_0.sky130_hd_inv_1_11.Y uo_out[7] uo_out[7] sky130_fd_pr__nfet_01v8 ad=0.0878 pd=0.92 as=0.169 ps=1.82 w=0.65 l=0.15
X1133 sky130_hd_xor_block_2.XORB sky130_hd_ro41_nand_0.sky130_hd_inv_1_10.A VDPWR VDPWR sky130_fd_pr__pfet_01v8 ad=0.135 pd=1.27 as=0.26 ps=2.52 w=1 l=0.15
X1134 sky130_hd_xor_block_2.XORB sky130_hd_ro41_nand_0.sky130_hd_inv_1_10.A uo_out[7] uo_out[7] sky130_fd_pr__nfet_01v8 ad=0.0878 pd=0.92 as=0.169 ps=1.82 w=0.65 l=0.15
X1135 a_23743_35715# a_23839_35537# uo_out[7] uo_out[7] sky130_fd_pr__nfet_01v8 ad=0.169 pd=1.82 as=0.0878 ps=0.92 w=0.65 l=0.15
X1136 VDPWR sky130_hd_ro37_nand_0.sky130_hd_inv_1_25.A sky130_hd_ro37_nand_0.sky130_hd_inv_1_25.Y VDPWR sky130_fd_pr__pfet_01v8 ad=0.26 pd=2.52 as=0.135 ps=1.27 w=1 l=0.15
X1137 sky130_hd_ro47_nand_0.sky130_hd_inv_1_2.Y sky130_hd_ro47_nand_0.sky130_hd_inv_1_3.Y uo_out[7] uo_out[7] sky130_fd_pr__nfet_01v8 ad=0.0878 pd=0.92 as=0.169 ps=1.82 w=0.65 l=0.15
X1138 sky130_hd_ro37_nand_0.sky130_hd_inv_1_4.A sky130_hd_ro37_nand_0.sky130_hd_inv_1_3.A uo_out[7] uo_out[7] sky130_fd_pr__nfet_01v8 ad=0.0878 pd=0.92 as=0.169 ps=1.82 w=0.65 l=0.15
X1139 sky130_hd_ro53_nand_0.sky130_hd_inv_1_37.Y sky130_hd_ro53_nand_0.sky130_hd_inv_1_38.Y VDPWR VDPWR sky130_fd_pr__pfet_01v8 ad=0.135 pd=1.27 as=0.26 ps=2.52 w=1 l=0.15
X1140 VDPWR sky130_hd_ro32_nand_0.sky130_hd_inv_1_31.Y sky130_hd_ro32_nand_0.sky130_hd_inv_1_30.Y VDPWR sky130_fd_pr__pfet_01v8 ad=0.26 pd=2.52 as=0.135 ps=1.27 w=1 l=0.15
X1141 uo_out[7] sky130_hd_ro53_nand_0.sky130_hd_inv_1_50.Y sky130_hd_ro53_nand_0.sky130_hd_inv_1_49.Y uo_out[7] sky130_fd_pr__nfet_01v8 ad=0.169 pd=1.82 as=0.0878 ps=0.92 w=0.65 l=0.15
X1142 uo_out[0] sky130_hd_inv_4_0.A uo_out[7] uo_out[7] sky130_fd_pr__nfet_01v8 ad=0.0878 pd=0.92 as=0.169 ps=1.82 w=0.65 l=0.15
X1143 uo_out[7] sky130_hd_div_by_2_4.Qb a_28742_3901# uo_out[7] sky130_fd_pr__nfet_01v8 ad=0.109 pd=1.36 as=0.0813 ps=0.83 w=0.42 l=0.15
X1144 uo_out[7] sky130_hd_ro37_nand_0.sky130_hd_inv_1_15.Y sky130_hd_ro37_nand_0.sky130_hd_inv_1_14.Y uo_out[7] sky130_fd_pr__nfet_01v8 ad=0.169 pd=1.82 as=0.0878 ps=0.92 w=0.65 l=0.15
X1145 uo_out[7] sky130_hd_ro37_nand_0.sky130_hd_inv_1_34.Y sky130_hd_ro37_nand_0.sky130_hd_inv_1_33.Y uo_out[7] sky130_fd_pr__nfet_01v8 ad=0.169 pd=1.82 as=0.0878 ps=0.92 w=0.65 l=0.15
X1146 sky130_hd_div_by_2_3.Qb a_28855_3301# VDPWR VDPWR sky130_fd_pr__pfet_01v8_hvt ad=0.26 pd=2.52 as=0.154 ps=1.34 w=1 l=0.15
X1147 sky130_hd_ro32_nand_0.sky130_hd_inv_1_8.Y sky130_hd_ro32_nand_0.sky130_hd_inv_1_9.Y VDPWR VDPWR sky130_fd_pr__pfet_01v8 ad=0.135 pd=1.27 as=0.26 ps=2.52 w=1 l=0.15
X1148 sky130_hd_ro53_nand_0.sky130_hd_inv_1_21.A sky130_hd_ro53_nand_0.sky130_hd_inv_1_20.A uo_out[7] uo_out[7] sky130_fd_pr__nfet_01v8 ad=0.0878 pd=0.92 as=0.169 ps=1.82 w=0.65 l=0.15
X1149 uo_out[7] sky130_hd_ro47_nand_0.sky130_hd_inv_1_35.Y sky130_hd_ro47_nand_0.sky130_hd_inv_1_34.Y uo_out[7] sky130_fd_pr__nfet_01v8 ad=0.169 pd=1.82 as=0.0878 ps=0.92 w=0.65 l=0.15
X1150 VDPWR sky130_hd_ro53_nand_0.sky130_hd_inv_1_5.Y sky130_hd_ro53_nand_0.sky130_hd_inv_1_4.Y VDPWR sky130_fd_pr__pfet_01v8 ad=0.26 pd=2.52 as=0.135 ps=1.27 w=1 l=0.15
X1151 uo_out[7] sky130_hd_ro37_nand_0.sky130_hd_inv_1_19.Y sky130_hd_ro37_nand_0.sky130_hd_inv_1_18.Y uo_out[7] sky130_fd_pr__nfet_01v8 ad=0.169 pd=1.82 as=0.0878 ps=0.92 w=0.65 l=0.15
X1152 VDPWR sky130_hd_ro47_nand_0.sky130_hd_inv_1_39.Y sky130_hd_ro47_nand_0.sky130_hd_inv_1_38.Y VDPWR sky130_fd_pr__pfet_01v8 ad=0.26 pd=2.52 as=0.135 ps=1.27 w=1 l=0.15
X1153 sky130_hd_ro47_nand_0.sky130_hd_inv_1_16.A sky130_hd_ro47_nand_0.sky130_hd_inv_1_15.A uo_out[7] uo_out[7] sky130_fd_pr__nfet_01v8 ad=0.0878 pd=0.92 as=0.169 ps=1.82 w=0.65 l=0.15
X1154 sky130_hd_ro32_nand_0.sky130_hd_inv_1_1.Y sky130_hd_ro32_nand_0.sky130_hd_inv_1_2.Y uo_out[7] uo_out[7] sky130_fd_pr__nfet_01v8 ad=0.0878 pd=0.92 as=0.169 ps=1.82 w=0.65 l=0.15
X1155 sky130_hd_ro53_nand_0.sky130_hd_inv_1_28.Y sky130_hd_ro53_nand_0.sky130_hd_inv_1_29.Y uo_out[7] uo_out[7] sky130_fd_pr__nfet_01v8 ad=0.0878 pd=0.92 as=0.169 ps=1.82 w=0.65 l=0.15
X1156 VDPWR sky130_hd_ro37_nand_0.sky130_hd_inv_1_18.Y sky130_hd_ro37_nand_0.sky130_hd_inv_1_17.Y VDPWR sky130_fd_pr__pfet_01v8 ad=0.26 pd=2.52 as=0.135 ps=1.27 w=1 l=0.15
X1157 sky130_hd_ro37_nand_0.sky130_hd_inv_1_12.Y sky130_hd_ro37_nand_0.sky130_hd_inv_1_13.Y uo_out[7] uo_out[7] sky130_fd_pr__nfet_01v8 ad=0.0878 pd=0.92 as=0.169 ps=1.82 w=0.65 l=0.15
X1158 sky130_hd_ro53_nand_0.sky130_hd_inv_1_2.Y sky130_hd_ro53_nand_0.sky130_hd_inv_1_3.Y uo_out[7] uo_out[7] sky130_fd_pr__nfet_01v8 ad=0.0878 pd=0.92 as=0.169 ps=1.82 w=0.65 l=0.15
X1159 uo_out[7] sky130_hd_ro47_nand_0.sky130_hd_inv_1_38.Y sky130_hd_ro47_nand_0.sky130_hd_inv_1_37.Y uo_out[7] sky130_fd_pr__nfet_01v8 ad=0.169 pd=1.82 as=0.0878 ps=0.92 w=0.65 l=0.15
X1160 VDPWR sky130_hd_ro53_nand_0.sky130_hd_inv_1_9.Y sky130_hd_ro53_nand_0.sky130_hd_inv_1_8.Y VDPWR sky130_fd_pr__pfet_01v8 ad=0.26 pd=2.52 as=0.135 ps=1.27 w=1 l=0.15
X1161 sky130_hd_ro32_nand_0.sky130_hd_nand2_1_0.Y ua[0] a_19286_4740# uo_out[7] sky130_fd_pr__nfet_01v8 ad=0.169 pd=1.82 as=0.0878 ps=0.92 w=0.65 l=0.15
X1162 a_21993_35563# a_21678_35715# uo_out[7] uo_out[7] sky130_fd_pr__nfet_01v8 ad=0.066 pd=0.745 as=0.109 ps=1.36 w=0.42 l=0.15
X1163 sky130_hd_xor_block_1.sky130_hd_xor2_1_0.A sky130_hd_xor_block_1.sky130_hd_inv_1_1.Y VDPWR VDPWR sky130_fd_pr__pfet_01v8 ad=0.135 pd=1.27 as=0.26 ps=2.52 w=1 l=0.15
X1164 uo_out[7] a_27631_2762# sky130_hd_div_by_2_2.Q uo_out[7] sky130_fd_pr__nfet_01v8 ad=0.0878 pd=0.92 as=0.169 ps=1.82 w=0.65 l=0.15
X1165 uo_out[7] sky130_hd_ro33_nand_0.sky130_hd_inv_1_13.Y sky130_hd_ro33_nand_0.sky130_hd_inv_1_12.Y uo_out[7] sky130_fd_pr__nfet_01v8 ad=0.169 pd=1.82 as=0.0878 ps=0.92 w=0.65 l=0.15
X1166 sky130_hd_xor_block_0.sky130_hd_xor2_1_0.B sky130_hd_xor_block_0.sky130_hd_inv_1_3.A uo_out[7] uo_out[7] sky130_fd_pr__nfet_01v8 ad=0.0878 pd=0.92 as=0.169 ps=1.82 w=0.65 l=0.15
X1167 sky130_hd_ro47_nand_0.sky130_hd_inv_1_7.A sky130_hd_ro47_nand_0.sky130_hd_inv_1_18.Y VDPWR VDPWR sky130_fd_pr__pfet_01v8 ad=0.135 pd=1.27 as=0.26 ps=2.52 w=1 l=0.15
X1168 a_28188_2653# sky130_hd_div_by_2_3.Q uo_out[7] uo_out[7] sky130_fd_pr__nfet_01v8 ad=0.109 pd=1.36 as=0.0567 ps=0.69 w=0.42 l=0.15
X1169 sky130_hd_div_by_2_0.Qb a_28855_2213# VDPWR VDPWR sky130_fd_pr__pfet_01v8_hvt ad=0.26 pd=2.52 as=0.154 ps=1.34 w=1 l=0.15
X1170 sky130_hd_ro32_nand_0.sky130_hd_inv_1_5.Y sky130_hd_ro32_nand_0.sky130_hd_inv_1_6.Y uo_out[7] uo_out[7] sky130_fd_pr__nfet_01v8 ad=0.0878 pd=0.92 as=0.169 ps=1.82 w=0.65 l=0.15
X1171 VDPWR sky130_hd_ro41_nand_0.sky130_hd_inv_1_3.A sky130_hd_ro41_nand_0.sky130_hd_inv_1_4.A VDPWR sky130_fd_pr__pfet_01v8 ad=0.26 pd=2.52 as=0.135 ps=1.27 w=1 l=0.15
X1172 uo_out[7] sky130_hd_ro41_nand_0.sky130_hd_inv_1_3.A sky130_hd_ro41_nand_0.sky130_hd_inv_1_4.A uo_out[7] sky130_fd_pr__nfet_01v8 ad=0.169 pd=1.82 as=0.0878 ps=0.92 w=0.65 l=0.15
X1173 VDPWR a_28188_1565# a_28195_1469# VDPWR sky130_fd_pr__pfet_01v8_hvt ad=0.0864 pd=0.91 as=0.166 ps=1.8 w=0.64 l=0.15
X1174 sky130_hd_ro53_nand_0.sky130_hd_inv_1_6.Y sky130_hd_ro53_nand_0.sky130_hd_inv_1_7.Y uo_out[7] uo_out[7] sky130_fd_pr__nfet_01v8 ad=0.0878 pd=0.92 as=0.169 ps=1.82 w=0.65 l=0.15
X1175 VDPWR sky130_hd_div_by_2_1.Qb a_28742_1725# VDPWR sky130_fd_pr__pfet_01v8_hvt ad=0.109 pd=1.36 as=0.0578 ps=0.695 w=0.42 l=0.15
X1176 sky130_hd_ro32_nand_0.sky130_hd_inv_1_12.Y sky130_hd_ro32_nand_0.sky130_hd_inv_1_13.Y VDPWR VDPWR sky130_fd_pr__pfet_01v8 ad=0.135 pd=1.27 as=0.26 ps=2.52 w=1 l=0.15
X1177 VDPWR sky130_hd_ro33_nand_0.sky130_hd_inv_1_8.Y sky130_hd_ro33_nand_0.sky130_hd_inv_1_7.Y VDPWR sky130_fd_pr__pfet_01v8 ad=0.26 pd=2.52 as=0.135 ps=1.27 w=1 l=0.15
X1178 uo_out[7] sky130_hd_xor_block_2.sky130_hd_xor2_1_0.A a_21179_33268# uo_out[7] sky130_fd_pr__nfet_01v8 ad=0.0878 pd=0.92 as=0.0878 ps=0.92 w=0.65 l=0.15
X1179 VDPWR sky130_hd_ro37_nand_0.sky130_hd_inv_1_23.Y sky130_hd_ro37_nand_0.sky130_hd_inv_1_22.Y VDPWR sky130_fd_pr__pfet_01v8 ad=0.26 pd=2.52 as=0.135 ps=1.27 w=1 l=0.15
X1180 sky130_hd_ro41_nand_0.sky130_hd_inv_1_1.A sky130_hd_ro41_nand_0.sky130_hd_inv_1_12.Y VDPWR VDPWR sky130_fd_pr__pfet_01v8 ad=0.135 pd=1.27 as=0.26 ps=2.52 w=1 l=0.15
X1181 sky130_hd_ro37_nand_0.sky130_hd_inv_1_16.Y sky130_hd_ro37_nand_0.sky130_hd_inv_1_17.Y VDPWR VDPWR sky130_fd_pr__pfet_01v8 ad=0.135 pd=1.27 as=0.26 ps=2.52 w=1 l=0.15
X1182 sky130_hd_ro41_nand_0.sky130_hd_inv_1_1.A sky130_hd_ro41_nand_0.sky130_hd_inv_1_12.Y uo_out[7] uo_out[7] sky130_fd_pr__nfet_01v8 ad=0.0878 pd=0.92 as=0.169 ps=1.82 w=0.65 l=0.15
X1183 uo_out[7] sky130_hd_ro47_nand_0.sky130_hd_inv_1_43.Y sky130_hd_ro47_nand_0.sky130_hd_inv_1_42.Y uo_out[7] sky130_fd_pr__nfet_01v8 ad=0.169 pd=1.82 as=0.0878 ps=0.92 w=0.65 l=0.15
X1184 sky130_hd_ro53_nand_0.sky130_hd_inv_1_18.A sky130_hd_ro53_nand_0.sky130_hd_inv_1_17.A VDPWR VDPWR sky130_fd_pr__pfet_01v8 ad=0.135 pd=1.27 as=0.26 ps=2.52 w=1 l=0.15
X1185 a_28544_3889# a_28324_3901# uo_out[7] uo_out[7] sky130_fd_pr__nfet_01v8 ad=0.0696 pd=0.765 as=0.121 ps=1.09 w=0.42 l=0.15
X1186 sky130_hd_ro47_nand_0.sky130_hd_inv_1_22.Y sky130_hd_ro47_nand_0.sky130_hd_inv_1_23.Y VDPWR VDPWR sky130_fd_pr__pfet_01v8 ad=0.135 pd=1.27 as=0.26 ps=2.52 w=1 l=0.15
X1187 sky130_hd_ro32_nand_0.sky130_hd_inv_1_9.Y sky130_hd_ro32_nand_0.sky130_hd_inv_1_10.Y VDPWR VDPWR sky130_fd_pr__pfet_01v8 ad=0.135 pd=1.27 as=0.26 ps=2.52 w=1 l=0.15
X1188 sky130_hd_ro53_nand_0.sky130_hd_inv_1_15.A sky130_hd_ro53_nand_0.sky130_hd_inv_1_14.A uo_out[7] uo_out[7] sky130_fd_pr__nfet_01v8 ad=0.0878 pd=0.92 as=0.169 ps=1.82 w=0.65 l=0.15
X1189 uo_out[7] a_22265_35537# a_22194_35563# uo_out[7] sky130_fd_pr__nfet_01v8 ad=0.121 pd=1.09 as=0.0989 ps=0.995 w=0.64 l=0.15
X1190 sky130_hd_ro47_nand_0.sky130_hd_inv_1_41.Y sky130_hd_ro47_nand_0.sky130_hd_inv_1_42.Y VDPWR VDPWR sky130_fd_pr__pfet_01v8 ad=0.135 pd=1.27 as=0.26 ps=2.52 w=1 l=0.15
X1191 VDPWR a_27536_1321# sky130_hd_div_by_2_1.Qb VDPWR sky130_fd_pr__pfet_01v8_hvt ad=0.154 pd=1.34 as=0.26 ps=2.52 w=1 l=0.15
X1192 sky130_hd_ro37_nand_0.sky130_hd_inv_1_20.Y sky130_hd_ro37_nand_0.sky130_hd_inv_1_21.Y VDPWR VDPWR sky130_fd_pr__pfet_01v8 ad=0.135 pd=1.27 as=0.26 ps=2.52 w=1 l=0.15
X1193 sky130_hd_ro37_nand_0.sky130_hd_inv_1_3.A sky130_hd_ro37_nand_0.sky130_hd_inv_1_2.A uo_out[7] uo_out[7] sky130_fd_pr__nfet_01v8 ad=0.0878 pd=0.92 as=0.169 ps=1.82 w=0.65 l=0.15
X1194 sky130_hd_ro33_nand_0.sky130_hd_inv_1_11.Y sky130_hd_ro33_nand_0.sky130_hd_inv_1_12.Y uo_out[7] uo_out[7] sky130_fd_pr__nfet_01v8 ad=0.0878 pd=0.92 as=0.169 ps=1.82 w=0.65 l=0.15
X1195 uo_out[7] sky130_hd_ro47_nand_0.sky130_hd_inv_1_32.Y sky130_hd_ro47_nand_0.sky130_hd_inv_1_31.Y uo_out[7] sky130_fd_pr__nfet_01v8 ad=0.169 pd=1.82 as=0.0878 ps=0.92 w=0.65 l=0.15
X1196 sky130_hd_ro53_nand_0.sky130_hd_inv_1_25.Y sky130_hd_ro53_nand_0.sky130_hd_inv_1_26.Y uo_out[7] uo_out[7] sky130_fd_pr__nfet_01v8 ad=0.0878 pd=0.92 as=0.169 ps=1.82 w=0.65 l=0.15
X1197 VDPWR sky130_hd_ro53_nand_0.sky130_hd_inv_1_2.Y sky130_hd_ro53_nand_0.sky130_hd_inv_1_1.Y VDPWR sky130_fd_pr__pfet_01v8 ad=0.26 pd=2.52 as=0.135 ps=1.27 w=1 l=0.15
X1198 sky130_hd_ro41_nand_0.sky130_hd_inv_1_16.Y sky130_hd_ro41_nand_0.sky130_hd_inv_1_17.Y VDPWR VDPWR sky130_fd_pr__pfet_01v8 ad=0.135 pd=1.27 as=0.26 ps=2.52 w=1 l=0.15
X1199 sky130_hd_ro41_nand_0.sky130_hd_inv_1_16.Y sky130_hd_ro41_nand_0.sky130_hd_inv_1_17.Y uo_out[7] uo_out[7] sky130_fd_pr__nfet_01v8 ad=0.0878 pd=0.92 as=0.169 ps=1.82 w=0.65 l=0.15
X1200 uo_out[7] sky130_hd_ro32_nand_0.sky130_hd_inv_1_13.Y sky130_hd_ro32_nand_0.sky130_hd_inv_1_12.Y uo_out[7] sky130_fd_pr__nfet_01v8 ad=0.169 pd=1.82 as=0.0878 ps=0.92 w=0.65 l=0.15
X1201 uo_out[7] sky130_hd_xor_block_1.sky130_hd_inv_1_1.Y sky130_hd_xor_block_1.sky130_hd_xor2_1_0.A uo_out[7] sky130_fd_pr__nfet_01v8 ad=0.169 pd=1.82 as=0.0878 ps=0.92 w=0.65 l=0.15
X1202 uo_out[7] sky130_hd_ro53_nand_0.sky130_hd_nand2_1_0.Y sky130_hd_ro53_nand_0.sky130_hd_inv_1_51.Y uo_out[7] sky130_fd_pr__nfet_01v8 ad=0.169 pd=1.82 as=0.0878 ps=0.92 w=0.65 l=0.15
X1203 sky130_hd_ro37_nand_0.sky130_hd_inv_1_9.Y sky130_hd_ro37_nand_0.sky130_hd_inv_1_10.Y uo_out[7] uo_out[7] sky130_fd_pr__nfet_01v8 ad=0.0878 pd=0.92 as=0.169 ps=1.82 w=0.65 l=0.15
X1204 VDPWR sky130_hd_ro32_nand_0.sky130_hd_inv_1_20.Y sky130_hd_ro32_nand_0.sky130_hd_inv_1_19.Y VDPWR sky130_fd_pr__pfet_01v8 ad=0.26 pd=2.52 as=0.135 ps=1.27 w=1 l=0.15
X1205 VDPWR sky130_hd_ro33_nand_0.sky130_hd_inv_1_17.Y sky130_hd_ro33_nand_0.sky130_hd_inv_1_16.Y VDPWR sky130_fd_pr__pfet_01v8 ad=0.26 pd=2.52 as=0.135 ps=1.27 w=1 l=0.15
X1206 VDPWR sky130_hd_ro53_nand_0.sky130_hd_inv_1_6.Y sky130_hd_ro53_nand_0.sky130_hd_inv_1_5.Y VDPWR sky130_fd_pr__pfet_01v8 ad=0.26 pd=2.52 as=0.135 ps=1.27 w=1 l=0.15
X1207 sky130_hd_div_by_2_3.Q a_28424_3247# uo_out[7] uo_out[7] sky130_fd_pr__nfet_01v8 ad=0.169 pd=1.82 as=0.0878 ps=0.92 w=0.65 l=0.15
X1208 a_27536_3497# a_27631_3850# uo_out[7] uo_out[7] sky130_fd_pr__nfet_01v8 ad=0.109 pd=1.36 as=0.097 ps=0.975 w=0.42 l=0.15
X1209 sky130_hd_ro53_nand_0.sky130_hd_inv_1_42.Y sky130_hd_ro53_nand_0.sky130_hd_inv_1_43.Y VDPWR VDPWR sky130_fd_pr__pfet_01v8 ad=0.135 pd=1.27 as=0.26 ps=2.52 w=1 l=0.15
X1210 sky130_hd_ro32_nand_0.sky130_hd_inv_1_22.Y sky130_hd_ro32_nand_0.sky130_hd_inv_1_23.Y uo_out[7] uo_out[7] sky130_fd_pr__nfet_01v8 ad=0.0878 pd=0.92 as=0.169 ps=1.82 w=0.65 l=0.15
X1211 sky130_hd_inv_4_0.A sky130_hd_inv_1_0.A uo_out[7] uo_out[7] sky130_fd_pr__nfet_01v8 ad=0.0878 pd=0.92 as=0.169 ps=1.82 w=0.65 l=0.15
X1212 sky130_hd_ro37_nand_0.sky130_hd_inv_1_25.Y sky130_hd_ro37_nand_0.sky130_hd_inv_1_25.A VDPWR VDPWR sky130_fd_pr__pfet_01v8 ad=0.135 pd=1.27 as=0.26 ps=2.52 w=1 l=0.15
X1213 VDPWR sky130_hd_xor_block_2.XOROUT sky130_hd_xor_block_1.sky130_hd_inv_1_3.A VDPWR sky130_fd_pr__pfet_01v8 ad=0.26 pd=2.52 as=0.135 ps=1.27 w=1 l=0.15
X1214 sky130_hd_ro37_nand_0.sky130_hd_inv_1_23.Y sky130_hd_ro37_nand_0.sky130_hd_inv_1_24.Y uo_out[7] uo_out[7] sky130_fd_pr__nfet_01v8 ad=0.0878 pd=0.92 as=0.169 ps=1.82 w=0.65 l=0.15
X1215 VDPWR sky130_hd_ro47_nand_0.sky130_hd_inv_1_40.Y sky130_hd_ro47_nand_0.sky130_hd_inv_1_39.Y VDPWR sky130_fd_pr__pfet_01v8 ad=0.26 pd=2.52 as=0.135 ps=1.27 w=1 l=0.15
X1216 sky130_hd_ro33_nand_0.sky130_hd_inv_1_3.Y sky130_hd_ro33_nand_0.sky130_hd_inv_1_4.Y uo_out[7] uo_out[7] sky130_fd_pr__nfet_01v8 ad=0.0878 pd=0.92 as=0.169 ps=1.82 w=0.65 l=0.15
X1217 uo_out[7] sky130_hd_ro53_nand_0.sky130_hd_inv_1_31.Y sky130_hd_ro53_nand_0.sky130_hd_inv_1_30.Y uo_out[7] sky130_fd_pr__nfet_01v8 ad=0.169 pd=1.82 as=0.0878 ps=0.92 w=0.65 l=0.15
X1218 uo_out[7] sky130_hd_ro33_nand_0.sky130_hd_inv_1_31.Y sky130_hd_ro33_nand_0.sky130_hd_inv_1_30.Y uo_out[7] sky130_fd_pr__nfet_01v8 ad=0.169 pd=1.82 as=0.0878 ps=0.92 w=0.65 l=0.15
X1219 sky130_hd_ro37_nand_0.sky130_hd_inv_1_14.Y sky130_hd_ro37_nand_0.sky130_hd_inv_1_15.Y uo_out[7] uo_out[7] sky130_fd_pr__nfet_01v8 ad=0.0878 pd=0.92 as=0.169 ps=1.82 w=0.65 l=0.15
X1220 sky130_hd_ro47_nand_0.sky130_hd_inv_1_35.Y sky130_hd_ro47_nand_0.sky130_hd_inv_1_35.A VDPWR VDPWR sky130_fd_pr__pfet_01v8 ad=0.135 pd=1.27 as=0.26 ps=2.52 w=1 l=0.15
X1221 sky130_hd_ro32_nand_0.sky130_hd_inv_1_19.Y sky130_hd_ro32_nand_0.sky130_hd_inv_1_20.Y uo_out[7] uo_out[7] sky130_fd_pr__nfet_01v8 ad=0.0878 pd=0.92 as=0.169 ps=1.82 w=0.65 l=0.15
X1222 sky130_hd_ro37_nand_0.sky130_hd_inv_1_13.Y sky130_hd_ro37_nand_0.sky130_hd_inv_1_14.Y VDPWR VDPWR sky130_fd_pr__pfet_01v8 ad=0.135 pd=1.27 as=0.26 ps=2.52 w=1 l=0.15
X1223 a_27903_2667# a_28188_2653# a_28123_2801# uo_out[7] sky130_fd_pr__special_nfet_01v8 ad=0.0684 pd=0.74 as=0.066 ps=0.745 w=0.36 l=0.15
X1224 uo_out[7] sky130_hd_ro32_nand_0.sky130_hd_inv_1_17.Y sky130_hd_ro32_nand_0.sky130_hd_inv_1_16.Y uo_out[7] sky130_fd_pr__nfet_01v8 ad=0.169 pd=1.82 as=0.0878 ps=0.92 w=0.65 l=0.15
X1225 sky130_hd_ro37_nand_0.sky130_hd_inv_1_26.Y sky130_hd_ro37_nand_0.sky130_hd_inv_1_27.Y uo_out[7] uo_out[7] sky130_fd_pr__nfet_01v8 ad=0.0878 pd=0.92 as=0.169 ps=1.82 w=0.65 l=0.15
X1226 sky130_hd_div_by_2_1.CLK a_28424_2159# uo_out[7] uo_out[7] sky130_fd_pr__nfet_01v8 ad=0.169 pd=1.82 as=0.0878 ps=0.92 w=0.65 l=0.15
X1227 sky130_hd_ro32_nand_0.sky130_hd_inv_1_26.Y sky130_hd_ro32_nand_0.sky130_hd_inv_1_27.Y VDPWR VDPWR sky130_fd_pr__pfet_01v8 ad=0.135 pd=1.27 as=0.26 ps=2.52 w=1 l=0.15
X1228 uo_out[7] sky130_hd_ro37_nand_0.sky130_hd_inv_1_8.Y sky130_hd_ro37_nand_0.sky130_hd_inv_1_1.A uo_out[7] sky130_fd_pr__nfet_01v8 ad=0.169 pd=1.82 as=0.0878 ps=0.92 w=0.65 l=0.15
X1229 sky130_hd_ro47_nand_0.sky130_hd_inv_1_34.Y sky130_hd_ro47_nand_0.sky130_hd_inv_1_35.Y uo_out[7] uo_out[7] sky130_fd_pr__nfet_01v8 ad=0.0878 pd=0.92 as=0.169 ps=1.82 w=0.65 l=0.15
X1230 VDPWR sky130_hd_ro53_nand_0.sky130_hd_inv_1_25.Y sky130_hd_ro53_nand_0.sky130_hd_inv_1_24.Y VDPWR sky130_fd_pr__pfet_01v8 ad=0.26 pd=2.52 as=0.135 ps=1.27 w=1 l=0.15
X1231 uo_out[7] sky130_hd_ro33_nand_0.sky130_hd_inv_1_15.Y sky130_hd_ro33_nand_0.sky130_hd_inv_1_14.Y uo_out[7] sky130_fd_pr__nfet_01v8 ad=0.169 pd=1.82 as=0.0878 ps=0.92 w=0.65 l=0.15
X1232 sky130_hd_ro47_nand_0.sky130_hd_inv_1_27.Y sky130_hd_ro47_nand_0.sky130_hd_inv_1_28.Y uo_out[7] uo_out[7] sky130_fd_pr__nfet_01v8 ad=0.0878 pd=0.92 as=0.169 ps=1.82 w=0.65 l=0.15
X1233 sky130_hd_ro33_nand_0.sky130_hd_inv_1_8.Y sky130_hd_ro33_nand_0.sky130_hd_inv_1_9.Y uo_out[7] uo_out[7] sky130_fd_pr__nfet_01v8 ad=0.0878 pd=0.92 as=0.169 ps=1.82 w=0.65 l=0.15
X1234 VDPWR sky130_hd_xor_block_2.sky130_hd_inv_1_3.A sky130_hd_xor_block_2.sky130_hd_xor2_1_0.B VDPWR sky130_fd_pr__pfet_01v8 ad=0.26 pd=2.52 as=0.135 ps=1.27 w=1 l=0.15
X1235 sky130_hd_ro37_nand_0.sky130_hd_nand2_1_0.Y sky130_hd_xor_block_3.XORB a_7207_31915# uo_out[7] sky130_fd_pr__nfet_01v8 ad=0.169 pd=1.82 as=0.0878 ps=0.92 w=0.65 l=0.15
X1236 VDPWR sky130_hd_ro33_nand_0.sky130_hd_inv_1_10.Y sky130_hd_ro33_nand_0.sky130_hd_inv_1_9.Y VDPWR sky130_fd_pr__pfet_01v8 ad=0.26 pd=2.52 as=0.135 ps=1.27 w=1 l=0.15
X1237 sky130_hd_ro47_nand_0.sky130_hd_inv_1_18.Y sky130_hd_ro47_nand_0.sky130_hd_inv_1_19.Y uo_out[7] uo_out[7] sky130_fd_pr__nfet_01v8 ad=0.0878 pd=0.92 as=0.169 ps=1.82 w=0.65 l=0.15
X1238 uo_out[7] sky130_hd_ro32_nand_0.sky130_hd_inv_1_14.Y sky130_hd_ro32_nand_0.sky130_hd_inv_1_13.Y uo_out[7] sky130_fd_pr__nfet_01v8 ad=0.169 pd=1.82 as=0.0878 ps=0.92 w=0.65 l=0.15
X1239 VDPWR sky130_hd_ro32_nand_0.sky130_hd_inv_1_21.Y sky130_hd_ro32_nand_0.sky130_hd_inv_1_20.Y VDPWR sky130_fd_pr__pfet_01v8 ad=0.26 pd=2.52 as=0.135 ps=1.27 w=1 l=0.15
X1240 sky130_hd_ro33_nand_0.sky130_hd_inv_1_12.Y sky130_hd_ro33_nand_0.sky130_hd_inv_1_13.Y uo_out[7] uo_out[7] sky130_fd_pr__nfet_01v8 ad=0.0878 pd=0.92 as=0.169 ps=1.82 w=0.65 l=0.15
X1241 a_24123_35537# clk uo_out[7] uo_out[7] sky130_fd_pr__nfet_01v8 ad=0.109 pd=1.36 as=0.0567 ps=0.69 w=0.42 l=0.15
X1242 VDPWR sky130_hd_ro33_nand_0.sky130_hd_inv_1_14.Y sky130_hd_ro33_nand_0.sky130_hd_inv_1_13.Y VDPWR sky130_fd_pr__pfet_01v8 ad=0.26 pd=2.52 as=0.135 ps=1.27 w=1 l=0.15
X1243 uo_out[7] sky130_hd_ro37_nand_0.sky130_hd_inv_1_32.Y sky130_hd_ro37_nand_0.sky130_hd_inv_1_31.Y uo_out[7] sky130_fd_pr__nfet_01v8 ad=0.169 pd=1.82 as=0.0878 ps=0.92 w=0.65 l=0.15
X1244 VDPWR sky130_hd_ro37_nand_0.sky130_hd_inv_1_31.Y sky130_hd_ro37_nand_0.sky130_hd_inv_1_30.Y VDPWR sky130_fd_pr__pfet_01v8 ad=0.26 pd=2.52 as=0.135 ps=1.27 w=1 l=0.15
X1245 sky130_hd_ro37_nand_0.sky130_hd_inv_1_22.Y sky130_hd_ro37_nand_0.sky130_hd_inv_1_23.Y VDPWR VDPWR sky130_fd_pr__pfet_01v8 ad=0.135 pd=1.27 as=0.26 ps=2.52 w=1 l=0.15
X1246 VDPWR sky130_hd_ro41_nand_0.sky130_hd_inv_1_10.A sky130_hd_xor_block_2.XORB VDPWR sky130_fd_pr__pfet_01v8 ad=0.26 pd=2.52 as=0.135 ps=1.27 w=1 l=0.15
X1247 a_28146_3523# a_27631_3850# VDPWR VDPWR sky130_fd_pr__pfet_01v8_hvt ad=0.0882 pd=0.84 as=0.111 ps=1.37 w=0.42 l=0.15
X1248 sky130_hd_ro32_nand_0.sky130_hd_nand2_1_0.Y ena VDPWR VDPWR sky130_fd_pr__pfet_01v8 ad=0.135 pd=1.27 as=0.26 ps=2.52 w=1 l=0.15
X1249 uo_out[7] sky130_hd_ro53_nand_0.sky130_hd_inv_1_37.Y sky130_hd_ro53_nand_0.sky130_hd_inv_1_36.Y uo_out[7] sky130_fd_pr__nfet_01v8 ad=0.169 pd=1.82 as=0.0878 ps=0.92 w=0.65 l=0.15
X1250 uo_out[7] sky130_hd_ro41_nand_0.sky130_hd_inv_1_10.A sky130_hd_xor_block_2.XORB uo_out[7] sky130_fd_pr__nfet_01v8 ad=0.169 pd=1.82 as=0.0878 ps=0.92 w=0.65 l=0.15
X1251 VDPWR sky130_hd_ro47_nand_0.sky130_hd_inv_1_37.Y sky130_hd_ro47_nand_0.sky130_hd_inv_1_36.Y VDPWR sky130_fd_pr__pfet_01v8 ad=0.26 pd=2.52 as=0.135 ps=1.27 w=1 l=0.15
X1252 sky130_hd_ro53_nand_0.sky130_hd_inv_1_27.Y sky130_hd_ro53_nand_0.sky130_hd_inv_1_28.Y uo_out[7] uo_out[7] sky130_fd_pr__nfet_01v8 ad=0.0878 pd=0.92 as=0.169 ps=1.82 w=0.65 l=0.15
X1253 sky130_hd_ro41_nand_0.sky130_hd_inv_1_37.Y sky130_hd_ro41_nand_0.sky130_hd_inv_1_38.Y VDPWR VDPWR sky130_fd_pr__pfet_01v8 ad=0.135 pd=1.27 as=0.26 ps=2.52 w=1 l=0.15
X1254 sky130_hd_ro41_nand_0.sky130_hd_inv_1_37.Y sky130_hd_ro41_nand_0.sky130_hd_inv_1_38.Y uo_out[7] uo_out[7] sky130_fd_pr__nfet_01v8 ad=0.0878 pd=0.92 as=0.169 ps=1.82 w=0.65 l=0.15
X1255 VDPWR sky130_hd_ro33_nand_0.sky130_hd_inv_1_28.Y sky130_hd_ro33_nand_0.sky130_hd_inv_1_27.Y VDPWR sky130_fd_pr__pfet_01v8 ad=0.26 pd=2.52 as=0.135 ps=1.27 w=1 l=0.15
X1256 sky130_hd_xor_block_0.XORB sky130_hd_ro53_nand_0.sky130_hd_inv_1_1.Y uo_out[7] uo_out[7] sky130_fd_pr__nfet_01v8 ad=0.0878 pd=0.92 as=0.169 ps=1.82 w=0.65 l=0.15
X1257 VDPWR sky130_hd_ro33_nand_0.sky130_hd_inv_1_19.Y sky130_hd_ro33_nand_0.sky130_hd_inv_1_18.Y VDPWR sky130_fd_pr__pfet_01v8 ad=0.26 pd=2.52 as=0.135 ps=1.27 w=1 l=0.15
X1258 VDPWR sky130_hd_ro37_nand_0.sky130_hd_nand2_1_0.Y sky130_hd_ro37_nand_0.sky130_hd_inv_1_35.Y VDPWR sky130_fd_pr__pfet_01v8 ad=0.26 pd=2.52 as=0.135 ps=1.27 w=1 l=0.15
X1259 sky130_hd_ro41_nand_0.sky130_hd_inv_1_22.Y sky130_hd_ro41_nand_0.sky130_hd_inv_1_23.Y VDPWR VDPWR sky130_fd_pr__pfet_01v8 ad=0.135 pd=1.27 as=0.26 ps=2.52 w=1 l=0.15
X1260 VDPWR sky130_hd_ro47_nand_0.sky130_hd_inv_1_26.Y sky130_hd_ro47_nand_0.sky130_hd_inv_1_25.Y VDPWR sky130_fd_pr__pfet_01v8 ad=0.26 pd=2.52 as=0.135 ps=1.27 w=1 l=0.15
X1261 sky130_hd_ro41_nand_0.sky130_hd_inv_1_22.Y sky130_hd_ro41_nand_0.sky130_hd_inv_1_23.Y uo_out[7] uo_out[7] sky130_fd_pr__nfet_01v8 ad=0.0878 pd=0.92 as=0.169 ps=1.82 w=0.65 l=0.15
X1262 sky130_hd_ro47_nand_0.sky130_hd_inv_1_31.Y sky130_hd_ro47_nand_0.sky130_hd_inv_1_32.Y uo_out[7] uo_out[7] sky130_fd_pr__nfet_01v8 ad=0.0878 pd=0.92 as=0.169 ps=1.82 w=0.65 l=0.15
X1263 sky130_hd_ro53_nand_0.sky130_hd_inv_1_1.Y sky130_hd_ro53_nand_0.sky130_hd_inv_1_2.Y VDPWR VDPWR sky130_fd_pr__pfet_01v8 ad=0.135 pd=1.27 as=0.26 ps=2.52 w=1 l=0.15
X1264 VDPWR sky130_hd_ro41_nand_0.sky130_hd_inv_1_5.A sky130_hd_ro41_nand_0.sky130_hd_inv_1_6.A VDPWR sky130_fd_pr__pfet_01v8 ad=0.26 pd=2.52 as=0.135 ps=1.27 w=1 l=0.15
X1265 uo_out[7] sky130_hd_ro53_nand_0.sky130_hd_inv_1_41.A sky130_hd_ro53_nand_0.sky130_hd_inv_1_41.Y uo_out[7] sky130_fd_pr__nfet_01v8 ad=0.169 pd=1.82 as=0.0878 ps=0.92 w=0.65 l=0.15
X1266 sky130_hd_ro33_nand_0.sky130_hd_inv_1_5.Y sky130_hd_ro33_nand_0.sky130_hd_inv_1_6.Y uo_out[7] uo_out[7] sky130_fd_pr__nfet_01v8 ad=0.0878 pd=0.92 as=0.169 ps=1.82 w=0.65 l=0.15
X1267 uo_out[7] sky130_hd_ro41_nand_0.sky130_hd_inv_1_5.A sky130_hd_ro41_nand_0.sky130_hd_inv_1_6.A uo_out[7] sky130_fd_pr__nfet_01v8 ad=0.169 pd=1.82 as=0.0878 ps=0.92 w=0.65 l=0.15
X1268 a_24479_35563# a_24259_35563# uo_out[7] uo_out[7] sky130_fd_pr__nfet_01v8 ad=0.0696 pd=0.765 as=0.121 ps=1.09 w=0.42 l=0.15
X1269 VDPWR sky130_hd_ro33_nand_0.sky130_hd_inv_1_7.Y sky130_hd_ro33_nand_0.sky130_hd_inv_1_6.Y VDPWR sky130_fd_pr__pfet_01v8 ad=0.26 pd=2.52 as=0.135 ps=1.27 w=1 l=0.15
X1270 sky130_hd_ro47_nand_0.sky130_hd_inv_1_35.A sky130_hd_ro47_nand_0.sky130_hd_inv_1_36.Y VDPWR VDPWR sky130_fd_pr__pfet_01v8 ad=0.135 pd=1.27 as=0.26 ps=2.52 w=1 l=0.15
X1271 uo_out[7] sky130_hd_ro47_nand_0.sky130_hd_inv_1_15.A sky130_hd_ro47_nand_0.sky130_hd_inv_1_16.A uo_out[7] sky130_fd_pr__nfet_01v8 ad=0.169 pd=1.82 as=0.0878 ps=0.92 w=0.65 l=0.15
X1272 VDPWR sky130_hd_ro53_nand_0.sky130_hd_inv_1_42.Y sky130_hd_ro53_nand_0.sky130_hd_inv_1_41.A VDPWR sky130_fd_pr__pfet_01v8 ad=0.26 pd=2.52 as=0.135 ps=1.27 w=1 l=0.15
X1273 a_22058_35537# clk uo_out[7] uo_out[7] sky130_fd_pr__nfet_01v8 ad=0.109 pd=1.36 as=0.0567 ps=0.69 w=0.42 l=0.15
X1274 sky130_hd_ro47_nand_0.sky130_hd_inv_1_44.Y sky130_hd_ro47_nand_0.sky130_hd_inv_1_45.Y uo_out[7] uo_out[7] sky130_fd_pr__nfet_01v8 ad=0.0878 pd=0.92 as=0.169 ps=1.82 w=0.65 l=0.15
X1275 sky130_hd_ro53_nand_0.sky130_hd_inv_1_20.A sky130_hd_ro53_nand_0.sky130_hd_inv_1_19.A VDPWR VDPWR sky130_fd_pr__pfet_01v8 ad=0.135 pd=1.27 as=0.26 ps=2.52 w=1 l=0.15
X1276 uo_out[7] sky130_hd_ro53_nand_0.sky130_hd_inv_1_45.Y sky130_hd_ro53_nand_0.sky130_hd_inv_1_44.Y uo_out[7] sky130_fd_pr__nfet_01v8 ad=0.169 pd=1.82 as=0.0878 ps=0.92 w=0.65 l=0.15
X1277 VDPWR sky130_hd_ro53_nand_0.sky130_hd_inv_1_27.Y sky130_hd_ro53_nand_0.sky130_hd_inv_1_26.Y VDPWR sky130_fd_pr__pfet_01v8 ad=0.26 pd=2.52 as=0.135 ps=1.27 w=1 l=0.15
X1278 uo_out[7] sky130_hd_ro37_nand_0.sky130_hd_inv_1_29.Y sky130_hd_ro37_nand_0.sky130_hd_inv_1_28.Y uo_out[7] sky130_fd_pr__nfet_01v8 ad=0.169 pd=1.82 as=0.0878 ps=0.92 w=0.65 l=0.15
X1279 VDPWR sky130_hd_ro53_nand_0.sky130_hd_inv_1_46.Y sky130_hd_ro53_nand_0.sky130_hd_inv_1_45.Y VDPWR sky130_fd_pr__pfet_01v8 ad=0.26 pd=2.52 as=0.135 ps=1.27 w=1 l=0.15
C0 a_21774_35537# a_22058_35537# 0.0322f
C1 a_28544_3889# sky130_hd_div_by_2_4.Qb 0.00176f
C2 sky130_hd_ro37_nand_0.sky130_hd_inv_1_2.A sky130_hd_ro37_nand_0.sky130_hd_inv_1_4.A 2.69e-19
C3 a_27831_3345# sky130_hd_div_by_2_4.Qb 0.0012f
C4 sky130_hd_ro33_nand_0.sky130_hd_inv_1_9.Y sky130_hd_ro37_nand_0.sky130_hd_inv_1_9.Y 2.28e-19
C5 sky130_hd_ro53_nand_0.sky130_hd_inv_1_4.Y sky130_hd_ro53_nand_0.sky130_hd_inv_1_3.Y 0.16f
C6 sky130_hd_ro37_nand_0.sky130_hd_inv_1_29.Y sky130_hd_ro37_nand_0.sky130_hd_inv_1_31.Y 5.04e-19
C7 sky130_hd_ro41_nand_0.sky130_hd_inv_1_34.Y sky130_hd_xor_block_1.XORB 3.16e-19
C8 VDPWR sky130_hd_ro33_nand_0.sky130_hd_inv_1_24.Y 0.436f
C9 a_28324_3901# a_28395_2712# 5.81e-20
C10 sky130_hd_ro41_nand_0.sky130_hd_inv_1_2.A VDPWR 0.441f
C11 a_28424_3247# a_28188_3741# 8.54e-19
C12 sky130_hd_ro47_nand_0.sky130_hd_inv_1_20.Y sky130_hd_xor_block_0.XORB 3.86e-19
C13 a_24868_30833# a_24950_30833# 0.00294f
C14 a_28188_3741# a_28395_3800# 0.273f
C15 sky130_hd_ro53_nand_0.sky130_hd_nand2_1_0.Y sky130_hd_ro53_nand_0.sky130_hd_inv_1_46.Y 5.97e-20
C16 sky130_hd_ro47_nand_0.sky130_hd_inv_1_20.Y sky130_hd_xor_block_1.XORB 6.56e-19
C17 a_28424_3247# a_28256_2257# 3.92e-20
C18 sky130_hd_xor_block_3.XORA VDPWR 3.86f
C19 a_27558_2979# a_28855_3301# 2.25e-19
C20 sky130_hd_xor_block_3.XORB sky130_hd_ro37_nand_0.sky130_hd_inv_1_9.Y 4.75e-19
C21 a_28256_3345# sky130_hd_div_by_2_4.Qb 0.00168f
C22 sky130_hd_ro47_nand_0.sky130_hd_inv_1_24.Y sky130_hd_xor_block_0.XORB 3.86e-19
C23 sky130_hd_ro33_nand_0.sky130_hd_inv_1_5.Y sky130_hd_ro33_nand_0.sky130_hd_inv_1_3.Y 5.04e-19
C24 VDPWR sky130_hd_ro53_nand_0.sky130_hd_inv_1_35.Y 0.448f
C25 sky130_hd_ro47_nand_0.sky130_hd_inv_1_32.Y sky130_hd_ro47_nand_0.sky130_hd_inv_1_30.Y 5.04e-19
C26 sky130_hd_xor_block_0.XORB sky130_hd_ro47_nand_0.sky130_hd_inv_1_15.A 3.86e-19
C27 sky130_hd_xor_block_1.XORB sky130_hd_ro47_nand_0.sky130_hd_inv_1_24.Y 6.56e-19
C28 sky130_hd_xor_block_1.XORB sky130_hd_ro47_nand_0.sky130_hd_inv_1_15.A 6.56e-19
C29 a_27536_1321# a_28195_1469# 2.25e-19
C30 a_28742_2813# sky130_hd_div_by_2_1.CLK 0.00284f
C31 sky130_hd_ro33_nand_0.sky130_hd_inv_1_10.Y sky130_hd_ro33_nand_0.sky130_hd_inv_1_9.Y 0.16f
C32 VDPWR sky130_hd_ro47_nand_0.sky130_hd_inv_1_33.Y 0.504f
C33 sky130_hd_xor_block_3.XORB sky130_hd_ro33_nand_0.sky130_hd_inv_1_20.Y 3.26e-19
C34 a_28324_3901# sky130_hd_div_by_2_3.Qb 0.00342f
C35 a_27558_1891# sky130_hd_div_by_2_2.Q 0.0231f
C36 sky130_hd_ro33_nand_0.sky130_hd_nand2_1_0.Y sky130_hd_ro37_nand_0.sky130_hd_inv_1_32.Y 1.13e-21
C37 a_22265_35537# a_22441_35929# 0.00772f
C38 sky130_hd_xor_block_2.XOROUT sky130_hd_xor_block_1.XOROUT 1.92e-19
C39 a_28256_2257# a_28195_1469# 0.00597f
C40 sky130_hd_ro41_nand_0.sky130_hd_inv_1_5.A sky130_hd_ro41_nand_0.sky130_hd_inv_1_4.A 0.16f
C41 sky130_hd_ro33_nand_0.sky130_hd_inv_1_18.Y sky130_hd_ro33_nand_0.sky130_hd_inv_1_20.Y 5.04e-19
C42 sky130_hd_ro47_nand_0.sky130_hd_inv_1_14.A VDPWR 0.438f
C43 sky130_hd_ro33_nand_0.sky130_hd_inv_1_10.Y sky130_hd_xor_block_3.XORB 3.26e-19
C44 sky130_hd_xor_block_2.XORB sky130_hd_ro37_nand_0.sky130_hd_inv_1_8.Y 3.07e-19
C45 sky130_hd_xor_block_2.XORB sky130_hd_ro41_nand_0.sky130_hd_inv_1_33.Y 5.1e-19
C46 ua[1] a_28146_1347# 5.01e-19
C47 sky130_hd_xor_block_2.XORB sky130_hd_ro37_nand_0.sky130_hd_inv_1_29.Y 3.07e-19
C48 a_23839_35537# a_23743_35715# 0.311f
C49 sky130_hd_xor_block_0.XOROUT sky130_hd_xor_block_1.XOROUT 6.82e-19
C50 sky130_hd_xor_block_3.XORB sky130_hd_ro37_nand_0.sky130_hd_inv_1_1.A 5.57e-19
C51 clk sky130_hd_dfxtp_1_1.Q 0.216f
C52 sky130_hd_ro41_nand_0.sky130_hd_inv_1_12.Y sky130_hd_ro41_nand_0.sky130_hd_inv_1_13.Y 0.16f
C53 a_28195_3645# a_28188_3741# 0.975f
C54 rst_n ui_in[0] 0.031f
C55 a_21179_33268# sky130_hd_xor_block_2.sky130_hd_inv_1_3.A 0.00265f
C56 sky130_hd_ro41_nand_0.sky130_hd_inv_1_27.Y sky130_hd_xor_block_1.XORB 3.16e-19
C57 a_28544_2801# sky130_hd_div_by_2_2.Qb 0.00167f
C58 VDPWR a_4631_27642# 1.7e-19
C59 a_28324_2813# a_28146_2435# 9.73e-19
C60 VDPWR sky130_hd_ro41_nand_0.sky130_hd_inv_1_14.Y 0.438f
C61 sky130_hd_ro32_nand_0.sky130_hd_inv_1_4.Y sky130_hd_div_by_2_4.Qb 0.00255f
C62 sky130_hd_ro32_nand_0.sky130_hd_inv_1_4.Y a_27536_3497# 5.82e-19
C63 sky130_hd_xor_block_2.XORB sky130_hd_ro41_nand_0.sky130_hd_inv_1_23.Y 5.1e-19
C64 ui_in[5] sky130_hd_ro41_nand_0.sky130_hd_nand2_1_0.Y 0.0778f
C65 a_27558_2979# a_27999_3091# 0.127f
C66 sky130_hd_xor_block_2.sky130_hd_inv_1_3.A sky130_hd_xor_block_2.XOROUT 1.65e-19
C67 sky130_hd_xor_block_1.sky130_hd_xor2_1_0.B sky130_hd_xor_block_1.XOROUT 0.0263f
C68 sky130_hd_xor_block_3.sky130_hd_xor2_1_0.B a_19445_33932# 0.34f
C69 sky130_hd_xor_block_2.XORB sky130_hd_xor_block_3.sky130_hd_xor2_1_0.B 6.53e-20
C70 sky130_hd_div_by_2_3.Q a_28340_3345# 4.41e-19
C71 a_27392_1891# a_27536_1321# 0.0084f
C72 a_28424_3247# sky130_hd_div_by_2_2.Qb 0.01f
C73 uo_out[0] ui_in[3] 0.207f
C74 sky130_hd_ro33_nand_0.sky130_hd_inv_1_23.Y sky130_hd_ro33_nand_0.sky130_hd_inv_1_24.Y 0.16f
C75 sky130_hd_ro37_nand_0.sky130_hd_inv_1_29.Y sky130_hd_ro37_nand_0.sky130_hd_inv_1_27.Y 5.04e-19
C76 sky130_hd_ro37_nand_0.sky130_hd_inv_1_30.Y sky130_hd_ro37_nand_0.sky130_hd_inv_1_31.Y 0.16f
C77 ui_in[5] sky130_hd_ro37_nand_0.sky130_hd_nand2_1_0.Y 0.00134f
C78 sky130_hd_ro32_nand_0.sky130_hd_inv_1_4.Y sky130_hd_ro32_nand_0.sky130_hd_inv_1_5.Y 0.16f
C79 sky130_hd_ro33_nand_0.sky130_hd_inv_1_15.Y sky130_hd_ro33_nand_0.sky130_hd_inv_1_14.Y 0.16f
C80 a_27392_1891# a_28256_2257# 0.0322f
C81 a_27631_1674# sky130_hd_div_by_2_2.Q 9.37e-20
C82 sky130_hd_ro47_nand_0.sky130_hd_nand2_1_0.Y sky130_hd_ro47_nand_0.sky130_hd_inv_1_41.Y 2.03e-19
C83 sky130_hd_xor_block_3.XORA sky130_hd_ro33_nand_0.sky130_hd_inv_1_11.Y 4.99e-19
C84 a_25118_30833# sky130_hd_xor_block_0.sky130_hd_xor2_1_0.A 0.0166f
C85 VDPWR a_28382_1891# 4.56e-19
C86 sky130_hd_ro53_nand_0.sky130_hd_inv_1_26.Y sky130_hd_ro53_nand_0.sky130_hd_inv_1_28.Y 5.04e-19
C87 sky130_hd_ro47_nand_0.sky130_hd_nand2_1_0.Y sky130_hd_ro47_nand_0.sky130_hd_inv_1_44.Y 0.0021f
C88 sky130_hd_xor_block_3.XORA sky130_hd_ro33_nand_0.sky130_hd_inv_1_23.Y 4.99e-19
C89 a_28855_2213# a_28855_3301# 7.51e-19
C90 VDPWR sky130_hd_ro53_nand_0.sky130_hd_inv_1_13.A 0.475f
C91 sky130_hd_ro41_nand_0.sky130_hd_inv_1_12.Y sky130_hd_xor_block_2.XORB 5.1e-19
C92 sky130_hd_ro37_nand_0.sky130_hd_inv_1_25.A sky130_hd_ro37_nand_0.sky130_hd_inv_1_25.Y 0.16f
C93 sky130_hd_div_by_2_2.Q a_27746_1891# 0.0056f
C94 sky130_hd_xor_block_3.XORA sky130_hd_ro33_nand_0.sky130_hd_inv_1_29.Y 0.00238f
C95 sky130_hd_xor_block_3.XOROUT sky130_hd_xor_block_3.XORB 6.82e-19
C96 sky130_hd_ro32_nand_0.sky130_hd_inv_1_26.Y ena 1.99e-19
C97 a_22612_35563# VDPWR 0.0754f
C98 sky130_hd_div_by_2_4.Q a_27926_3345# 3.6e-19
C99 a_28188_1565# ua[0] 9.44e-19
C100 sky130_hd_ro37_nand_0.sky130_hd_inv_1_14.Y sky130_hd_xor_block_3.XORB 4.75e-19
C101 a_27392_1891# a_27999_2003# 0.141f
C102 a_27392_2979# sky130_hd_ro32_nand_0.sky130_hd_inv_1_1.Y 7.45e-20
C103 sky130_hd_ro41_nand_0.sky130_hd_inv_1_34.Y sky130_hd_ro41_nand_0.sky130_hd_nand2_1_0.Y 5.97e-20
C104 ui_in[5] ui_in[4] 4.73f
C105 sky130_hd_xor_block_1.sky130_hd_xor2_1_0.A a_23018_31990# 4.43e-19
C106 a_25118_30583# a_24868_30833# 0.00723f
C107 sky130_hd_xor_block_3.XORB sky130_hd_ro33_nand_0.sky130_hd_inv_1_31.Y 3.26e-19
C108 sky130_hd_ro33_nand_0.sky130_hd_nand2_1_0.Y VDPWR 0.5f
C109 sky130_hd_xor_block_3.XORB sky130_hd_ro37_nand_0.sky130_hd_inv_1_28.Y 4.75e-19
C110 sky130_hd_ro53_nand_0.sky130_hd_inv_1_6.Y sky130_hd_xor_block_0.XORB 0.00102f
C111 sky130_hd_ro53_nand_0.sky130_hd_inv_1_45.Y sky130_hd_ro53_nand_0.sky130_hd_inv_1_44.Y 0.16f
C112 sky130_hd_ro41_nand_0.sky130_hd_inv_1_6.A sky130_hd_ro41_nand_0.sky130_hd_inv_1_4.A 5.04e-19
C113 sky130_hd_ro32_nand_0.sky130_hd_inv_1_25.Y sky130_hd_ro32_nand_0.sky130_hd_inv_1_24.Y 0.16f
C114 uo_out[0] a_21774_35537# 2.46e-19
C115 sky130_hd_ro32_nand_0.sky130_hd_inv_1_13.Y ua[0] 0.011f
C116 a_22194_35563# a_22612_35563# 3.39e-19
C117 a_27746_2979# a_27831_3345# 0.0373f
C118 a_22936_31990# sky130_hd_xor_block_1.sky130_hd_xor2_1_0.A 0.0956f
C119 ua[1] a_28395_1624# 8.03e-19
C120 a_27631_2762# a_27536_3497# 1.44e-21
C121 sky130_hd_xor_block_0.XORB sky130_hd_ro47_nand_0.sky130_hd_inv_1_13.A 3.86e-19
C122 sky130_hd_ro47_nand_0.sky130_hd_inv_1_43.Y VDPWR 0.416f
C123 a_28188_2653# a_28742_2813# 0.0622f
C124 VDPWR sky130_hd_ro47_nand_0.sky130_hd_inv_1_26.Y 0.436f
C125 a_28544_2801# a_28395_2712# 0.00553f
C126 a_28742_1725# a_28571_1347# 0.00123f
C127 a_24123_35537# a_23839_35537# 0.0322f
C128 a_27903_3755# sky130_hd_div_by_2_4.Qb 0.0141f
C129 a_28195_3645# sky130_hd_div_by_2_2.Qb 3.75e-21
C130 sky130_hd_ro37_nand_0.sky130_hd_inv_1_34.Y sky130_hd_ro37_nand_0.sky130_hd_nand2_1_0.Y 0.0021f
C131 sky130_hd_xor_block_0.sky130_hd_inv_1_3.A sky130_hd_xor_block_1.XOROUT 0.163f
C132 sky130_hd_ro37_nand_0.sky130_hd_inv_1_26.Y sky130_hd_ro37_nand_0.sky130_hd_inv_1_28.Y 5.04e-19
C133 sky130_hd_ro41_nand_0.sky130_hd_inv_1_15.Y sky130_hd_ro41_nand_0.sky130_hd_inv_1_13.Y 5.04e-19
C134 sky130_hd_xor_block_1.XORB sky130_hd_ro47_nand_0.sky130_hd_inv_1_13.A 6.56e-19
C135 VDPWR a_28188_1565# 0.629f
C136 sky130_hd_xor_block_2.XORB sky130_hd_ro37_nand_0.sky130_hd_inv_1_30.Y 3.07e-19
C137 sky130_hd_xor_block_2.sky130_hd_xor2_1_0.A sky130_hd_xor_block_2.sky130_hd_inv_1_1.Y 0.149f
C138 sky130_hd_ro53_nand_0.sky130_hd_inv_1_18.A sky130_hd_xor_block_0.XORB 7.87e-19
C139 a_27831_2257# a_27926_2257# 0.00772f
C140 sky130_hd_div_by_2_1.CLK sky130_hd_div_by_2_2.Q 0.00294f
C141 sky130_hd_ro33_nand_0.sky130_hd_inv_1_16.Y sky130_hd_ro33_nand_0.sky130_hd_inv_1_15.Y 0.16f
C142 sky130_hd_ro47_nand_0.sky130_hd_inv_1_14.A sky130_hd_ro47_nand_0.sky130_hd_inv_1_16.A 5.04e-19
C143 a_28424_3247# a_28395_2712# 0.00305f
C144 sky130_hd_xor_block_0.XORB sky130_hd_ro53_nand_0.sky130_hd_inv_1_26.Y 7.87e-19
C145 a_28395_2712# a_28395_3800# 6.62e-19
C146 VDPWR sky130_hd_ro41_nand_0.sky130_hd_inv_1_17.Y 0.448f
C147 sky130_hd_ro41_nand_0.sky130_hd_inv_1_2.A sky130_hd_ro41_nand_0.sky130_hd_inv_1_3.A 0.152f
C148 a_27392_1891# sky130_hd_div_by_2_2.Qb 0.00376f
C149 sky130_hd_xor_block_2.XORB sky130_hd_ro41_nand_0.sky130_hd_inv_1_7.A 0.00226f
C150 ui_in[4] sky130_hd_ro37_nand_0.sky130_hd_nand2_1_0.Y 0.0783f
C151 sky130_hd_xor_block_2.XORB sky130_hd_ro37_nand_0.sky130_hd_inv_1_16.Y 3.07e-19
C152 ui_in[2] ui_in[1] 0.031f
C153 VDPWR sky130_hd_ro32_nand_0.sky130_hd_inv_1_13.Y 0.417f
C154 sky130_hd_xor_block_1.sky130_hd_xor2_1_0.A sky130_hd_xor_block_1.XORB 0.012f
C155 sky130_hd_div_by_2_2.Qb a_28123_2801# 9.61e-19
C156 sky130_hd_ro47_nand_0.sky130_hd_inv_1_12.A sky130_hd_xor_block_0.XORB 3.86e-19
C157 sky130_hd_ro37_nand_0.sky130_hd_inv_1_34.Y ui_in[4] 5.12e-20
C158 sky130_hd_ro32_nand_0.sky130_hd_inv_1_10.Y sky130_hd_ro32_nand_0.sky130_hd_inv_1_12.Y 5.04e-19
C159 sky130_hd_div_by_2_3.Qb a_28544_2801# 9.18e-19
C160 sky130_hd_ro47_nand_0.sky130_hd_inv_1_28.Y sky130_hd_ro47_nand_0.sky130_hd_inv_1_30.Y 5.04e-19
C161 sky130_hd_ro33_nand_0.sky130_hd_inv_1_8.Y sky130_hd_ro33_nand_0.sky130_hd_inv_1_6.Y 5.04e-19
C162 sky130_hd_ro47_nand_0.sky130_hd_inv_1_12.A sky130_hd_xor_block_1.XORB 6.56e-19
C163 sky130_hd_xor_block_3.XOROUT sky130_hd_xor_block_2.sky130_hd_xor2_1_0.B 0.00782f
C164 a_28188_3741# a_28324_2813# 5.37e-21
C165 sky130_hd_xor_block_3.XORB sky130_hd_ro33_nand_0.sky130_hd_inv_1_12.Y 3.26e-19
C166 VDPWR sky130_hd_ro47_nand_0.sky130_hd_inv_1_3.Y 0.474f
C167 sky130_hd_ro47_nand_0.sky130_hd_inv_1_31.Y sky130_hd_xor_block_0.XORB 3.86e-19
C168 sky130_hd_ro53_nand_0.sky130_hd_inv_1_14.A VDPWR 0.447f
C169 sky130_hd_xor_block_2.XORB sky130_hd_ro41_nand_0.sky130_hd_inv_1_15.Y 5.1e-19
C170 ui_in[5] sky130_hd_xor_block_3.XORB 2.54e-20
C171 VDPWR sky130_hd_ro53_nand_0.sky130_hd_inv_1_32.Y 0.46f
C172 VDPWR a_28382_2979# 4.56e-19
C173 sky130_hd_ro37_nand_0.sky130_hd_inv_1_4.A sky130_hd_ro41_nand_0.sky130_hd_inv_1_7.A 6.22e-19
C174 sky130_hd_ro53_nand_0.sky130_hd_inv_1_37.Y sky130_hd_ro53_nand_0.sky130_hd_inv_1_36.Y 0.16f
C175 a_28256_2257# a_28324_2813# 0.00205f
C176 a_28395_2712# a_28195_1469# 8.17e-21
C177 sky130_hd_ro47_nand_0.sky130_hd_inv_1_31.Y sky130_hd_xor_block_1.XORB 6.56e-19
C178 a_27631_3850# a_28188_3741# 0.0486f
C179 sky130_hd_ro37_nand_0.sky130_hd_inv_1_2.A sky130_hd_ro37_nand_0.sky130_hd_inv_1_1.A 0.157f
C180 sky130_hd_ro33_nand_0.sky130_hd_inv_1_16.Y sky130_hd_ro33_nand_0.sky130_hd_inv_1_17.Y 0.16f
C181 a_28424_3247# sky130_hd_div_by_2_3.Qb 0.0499f
C182 sky130_hd_div_by_2_3.Qb a_28395_3800# 0.00318f
C183 sky130_hd_ro32_nand_0.sky130_hd_inv_1_13.Y sky130_hd_ro32_nand_0.sky130_hd_inv_1_14.Y 0.16f
C184 VDPWR a_27926_2257# 0.00292f
C185 VDPWR sky130_hd_xor_block_2.sky130_hd_inv_1_1.Y 0.469f
C186 sky130_hd_xor_block_3.XORA a_19527_33932# 4.17e-19
C187 sky130_hd_xor_block_3.XORB sky130_hd_ro37_nand_0.sky130_hd_inv_1_3.A 0.00141f
C188 VDPWR sky130_hd_ro47_nand_0.sky130_hd_inv_1_42.Y 0.424f
C189 sky130_hd_xor_block_3.XORB sky130_hd_ro33_nand_0.sky130_hd_inv_1_19.Y 3.26e-19
C190 sky130_hd_ro47_nand_0.sky130_hd_inv_1_27.Y sky130_hd_xor_block_0.XORB 3.86e-19
C191 sky130_hd_ro53_nand_0.sky130_hd_inv_1_37.Y sky130_hd_xor_block_0.XORB 7.87e-19
C192 sky130_hd_ro53_nand_0.sky130_hd_inv_1_24.Y VDPWR 0.44f
C193 sky130_hd_xor_block_1.XORB sky130_hd_ro47_nand_0.sky130_hd_inv_1_27.Y 6.56e-19
C194 sky130_hd_ro32_nand_0.sky130_hd_inv_1_6.Y ena 1.99e-19
C195 a_28195_3645# a_28395_2712# 1.22e-20
C196 a_21678_35715# a_21774_35537# 0.311f
C197 uo_out[0] uio_in[6] 0.00103f
C198 sky130_hd_ro33_nand_0.sky130_hd_nand2_1_0.Y sky130_hd_ro33_nand_0.sky130_hd_inv_1_29.Y 6.18e-19
C199 sky130_hd_xor_block_0.XORB sky130_hd_ro47_nand_0.sky130_hd_inv_1_35.A 3.86e-19
C200 ui_in[6] sky130_hd_xor_block_0.XORB 0.00311f
C201 sky130_hd_ro32_nand_0.sky130_hd_inv_1_2.Y sky130_hd_div_by_2_4.Qb 0.00408f
C202 sky130_hd_ro33_nand_0.sky130_hd_inv_1_18.Y sky130_hd_ro33_nand_0.sky130_hd_inv_1_19.Y 0.16f
C203 a_27903_1579# a_28188_1565# 0.0322f
C204 sky130_hd_ro41_nand_0.sky130_hd_inv_1_18.Y sky130_hd_ro41_nand_0.sky130_hd_inv_1_17.Y 0.16f
C205 a_22016_35929# a_22065_35837# 6.32e-19
C206 sky130_hd_xor_block_1.XORB sky130_hd_ro41_nand_0.sky130_hd_inv_1_37.Y 0.00128f
C207 sky130_hd_xor_block_1.XORB ui_in[6] 0.381f
C208 sky130_hd_xor_block_1.XORB sky130_hd_ro47_nand_0.sky130_hd_inv_1_35.A 6.56e-19
C209 sky130_hd_xor_block_3.XORB sky130_hd_ro37_nand_0.sky130_hd_nand2_1_0.Y 0.234f
C210 sky130_hd_div_by_2_1.Qb sky130_hd_div_by_2_2.Q 7.66e-19
C211 sky130_hd_xor_block_3.XORB sky130_hd_ro33_nand_0.sky130_hd_inv_1_1.Y 3.26e-19
C212 sky130_hd_ro37_nand_0.sky130_hd_inv_1_9.Y sky130_hd_ro37_nand_0.sky130_hd_inv_1_8.Y 0.16f
C213 sky130_hd_div_by_2_4.Q a_27392_2979# 0.309f
C214 a_27558_1891# a_27536_1321# 6.08e-19
C215 sky130_hd_ro37_nand_0.sky130_hd_inv_1_34.Y sky130_hd_xor_block_3.XORB 0.00402f
C216 sky130_hd_inv_1_0.A a_22065_35837# 0.0116f
C217 a_27392_1891# a_27536_2409# 0.00737f
C218 sky130_hd_ro53_nand_0.sky130_hd_inv_1_22.A sky130_hd_xor_block_0.XORB 7.87e-19
C219 ua[0] sky130_hd_div_by_2_4.Qb 0.292f
C220 ua[0] a_27536_3497# 2.72e-19
C221 VDPWR sky130_hd_ro47_nand_0.sky130_hd_inv_1_39.Y 0.434f
C222 a_21261_33268# sky130_hd_xor_block_3.XOROUT 2.15e-19
C223 ena sky130_hd_ro32_nand_0.sky130_hd_inv_1_31.Y 0.00104f
C224 sky130_hd_xor_block_3.sky130_hd_inv_1_1.Y sky130_hd_xor_block_2.sky130_hd_inv_1_3.A 4.15e-20
C225 sky130_hd_ro33_nand_0.sky130_hd_inv_1_21.Y sky130_hd_ro33_nand_0.sky130_hd_inv_1_20.Y 0.16f
C226 a_28256_2257# a_27558_1891# 0.197f
C227 a_28195_3645# sky130_hd_div_by_2_3.Qb 0.00298f
C228 sky130_hd_ro53_nand_0.sky130_hd_inv_1_18.A sky130_hd_ro53_nand_0.sky130_hd_inv_1_19.A 0.16f
C229 a_27903_2667# sky130_hd_div_by_2_2.Q 0.0084f
C230 sky130_hd_xor_block_3.XORB sky130_hd_ro37_nand_0.sky130_hd_inv_1_20.Y 4.75e-19
C231 a_28188_2653# sky130_hd_div_by_2_2.Q 0.00642f
C232 a_28195_2557# a_28855_3301# 6.08e-19
C233 sky130_hd_div_by_2_2.Qb a_28324_2813# 0.0261f
C234 VDPWR sky130_hd_ro33_nand_0.sky130_hd_inv_1_4.Y 0.504f
C235 ui_in[4] sky130_hd_xor_block_3.XORB 0.382f
C236 sky130_hd_ro32_nand_0.sky130_hd_inv_1_25.Y ua[0] 0.011f
C237 ua[0] sky130_hd_ro32_nand_0.sky130_hd_inv_1_5.Y 0.0115f
C238 sky130_hd_ro32_nand_0.sky130_hd_inv_1_20.Y sky130_hd_ro32_nand_0.sky130_hd_inv_1_19.Y 0.16f
C239 sky130_hd_xor_block_2.XORB sky130_hd_ro41_nand_0.sky130_hd_inv_1_9.A 0.00744f
C240 VDPWR sky130_hd_ro33_nand_0.sky130_hd_inv_1_28.Y 0.439f
C241 sky130_hd_div_by_2_4.Q a_28146_3523# 6e-19
C242 a_27392_1891# sky130_hd_div_by_2_3.Qb 2.18e-20
C243 a_27631_3850# sky130_hd_div_by_2_2.Qb 1.92e-21
C244 a_27831_3345# a_27999_3091# 0.24f
C245 a_27746_2979# a_27631_2762# 5.32e-19
C246 VDPWR sky130_hd_div_by_2_4.Qb 0.399f
C247 VDPWR a_27536_3497# 0.21f
C248 a_27558_1891# a_27999_2003# 0.127f
C249 sky130_hd_ro32_nand_0.sky130_hd_inv_1_25.Y sky130_hd_ro32_nand_0.sky130_hd_inv_1_27.Y 5.04e-19
C250 sky130_hd_div_by_2_3.Qb a_28123_2801# 6.24e-19
C251 a_24130_35837# a_24081_35929# 6.32e-19
C252 sky130_hd_div_by_2_0.Qb a_28395_1624# 0.00287f
C253 sky130_hd_ro33_nand_0.sky130_hd_inv_1_7.Y sky130_hd_ro33_nand_0.sky130_hd_inv_1_6.Y 0.16f
C254 sky130_hd_ro37_nand_0.sky130_hd_inv_1_8.Y sky130_hd_ro37_nand_0.sky130_hd_inv_1_1.A 0.152f
C255 sky130_hd_xor_block_3.XORA sky130_hd_ro33_nand_0.sky130_hd_inv_1_14.Y 4.99e-19
C256 a_28146_1347# a_28324_1725# 9.73e-19
C257 a_28424_2159# a_28395_1624# 0.00305f
C258 VDPWR a_19695_33932# 0.291f
C259 a_28742_2813# a_28571_2435# 0.00123f
C260 sky130_hd_xor_block_2.XORB sky130_hd_ro37_nand_0.sky130_hd_inv_1_24.Y 3.07e-19
C261 a_28195_2557# a_28395_1624# 1.22e-20
C262 VDPWR a_19695_33682# 1.91e-19
C263 a_27631_1674# a_27536_1321# 0.108f
C264 a_28256_3345# a_27999_3091# 0.0368f
C265 VDPWR sky130_hd_ro32_nand_0.sky130_hd_inv_1_5.Y 0.417f
C266 VDPWR sky130_hd_ro47_nand_0.sky130_hd_inv_1_10.A 0.438f
C267 sky130_hd_div_by_2_2.Q a_27392_2979# 2.96e-19
C268 sky130_hd_ro47_nand_0.sky130_hd_inv_1_23.Y sky130_hd_xor_block_0.XORB 3.86e-19
C269 VDPWR sky130_hd_ro32_nand_0.sky130_hd_inv_1_25.Y 0.419f
C270 sky130_hd_ro47_nand_0.sky130_hd_inv_1_23.Y sky130_hd_xor_block_1.XORB 6.56e-19
C271 a_28742_2813# sky130_hd_div_by_2_3.Q 0.00161f
C272 sky130_hd_ro47_nand_0.sky130_hd_inv_1_13.A sky130_hd_ro47_nand_0.sky130_hd_inv_1_15.A 5.04e-19
C273 sky130_hd_xor_block_0.XOROUT a_24130_35837# 0.244f
C274 sky130_hd_ro33_nand_0.sky130_hd_inv_1_9.Y sky130_hd_xor_block_3.XORB 3.26e-19
C275 sky130_hd_ro32_nand_0.sky130_hd_inv_1_17.Y sky130_hd_ro32_nand_0.sky130_hd_inv_1_15.Y 5.04e-19
C276 ui_in[5] sky130_hd_ro41_nand_0.sky130_hd_inv_1_37.Y 3.2e-20
C277 ui_in[5] ui_in[6] 4.44f
C278 a_22441_35929# sky130_hd_dfxtp_1_1.Q 4.53e-20
C279 sky130_hd_ro53_nand_0.sky130_hd_inv_1_40.Y VDPWR 0.435f
C280 sky130_hd_ro32_nand_0.sky130_hd_inv_1_3.Y sky130_hd_ro32_nand_0.sky130_hd_inv_1_4.Y 0.16f
C281 a_19445_33932# sky130_hd_xor_block_3.sky130_hd_xor2_1_0.A 0.0956f
C282 sky130_hd_xor_block_2.XORB sky130_hd_xor_block_3.sky130_hd_xor2_1_0.A 2.68e-19
C283 a_27558_1891# sky130_hd_div_by_2_2.Qb 0.00244f
C284 sky130_hd_ro32_nand_0.sky130_hd_inv_1_30.Y ua[0] 0.0139f
C285 a_28324_3901# sky130_hd_div_by_2_4.Qb 0.0154f
C286 a_27558_2979# a_27831_3345# 0.083f
C287 sky130_hd_ro41_nand_0.sky130_hd_inv_1_33.Y sky130_hd_xor_block_1.XORB 3.16e-19
C288 sky130_hd_ro53_nand_0.sky130_hd_inv_1_44.Y sky130_hd_ro53_nand_0.sky130_hd_inv_1_42.Y 5.04e-19
C289 VDPWR sky130_hd_xor_block_3.sky130_hd_inv_1_3.A 0.459f
C290 sky130_hd_ro37_nand_0.sky130_hd_inv_1_2.A sky130_hd_ro37_nand_0.sky130_hd_inv_1_3.A 0.152f
C291 sky130_hd_xor_block_1.XORB sky130_hd_ro41_nand_0.sky130_hd_inv_1_23.Y 3.16e-19
C292 a_27631_1674# a_27999_2003# 7.11e-19
C293 a_28395_2712# a_28324_2813# 0.24f
C294 sky130_hd_ro53_nand_0.sky130_hd_inv_1_22.Y sky130_hd_xor_block_0.XORB 7.87e-19
C295 a_27903_2667# a_28146_2435# 0.00851f
C296 sky130_hd_xor_block_3.XORA sky130_hd_ro33_nand_0.sky130_hd_inv_1_16.Y 4.99e-19
C297 sky130_hd_ro41_nand_0.sky130_hd_nand2_1_0.Y sky130_hd_ro41_nand_0.sky130_hd_inv_1_37.Y 6.18e-19
C298 VDPWR sky130_hd_ro47_nand_0.sky130_hd_inv_1_41.Y 0.434f
C299 sky130_hd_ro37_nand_0.sky130_hd_inv_1_29.Y sky130_hd_ro37_nand_0.sky130_hd_inv_1_28.Y 0.16f
C300 sky130_hd_ro37_nand_0.sky130_hd_inv_1_21.Y sky130_hd_ro37_nand_0.sky130_hd_inv_1_22.Y 0.16f
C301 a_27999_2003# a_27746_1891# 3.39e-19
C302 sky130_hd_ro32_nand_0.sky130_hd_inv_1_18.Y ua[0] 0.011f
C303 a_28256_3345# a_27558_2979# 0.197f
C304 sky130_hd_xor_block_3.XOROUT sky130_hd_xor_block_3.sky130_hd_xor2_1_0.B 0.0272f
C305 sky130_hd_div_by_2_0.Qb a_27957_1891# 0.00168f
C306 sky130_hd_ro33_nand_0.sky130_hd_inv_1_18.Y sky130_hd_xor_block_3.XORB 3.26e-19
C307 sky130_hd_ro32_nand_0.sky130_hd_inv_1_29.Y ena 4.66e-19
C308 sky130_hd_ro53_nand_0.sky130_hd_inv_1_47.Y sky130_hd_xor_block_0.XORB 0.00126f
C309 VDPWR sky130_hd_ro47_nand_0.sky130_hd_inv_1_44.Y 0.416f
C310 sky130_hd_ro32_nand_0.sky130_hd_inv_1_8.Y ena 1.99e-19
C311 sky130_hd_ro37_nand_0.sky130_hd_inv_1_26.Y sky130_hd_xor_block_3.XORB 4.75e-19
C312 sky130_hd_ro37_nand_0.sky130_hd_inv_1_23.Y sky130_hd_ro37_nand_0.sky130_hd_inv_1_24.Y 0.16f
C313 a_28395_1624# a_28324_1725# 0.24f
C314 sky130_hd_ro37_nand_0.sky130_hd_nand2_1_0.Y sky130_hd_ro41_nand_0.sky130_hd_inv_1_37.Y 6.22e-19
C315 sky130_hd_ro32_nand_0.sky130_hd_inv_1_30.Y VDPWR 0.419f
C316 sky130_hd_div_by_2_1.CLK a_27536_1321# 2.59e-19
C317 sky130_hd_div_by_2_4.Q sky130_hd_div_by_2_3.Q 0.00294f
C318 VDPWR sky130_hd_ro33_nand_0.sky130_hd_inv_1_3.Y 0.474f
C319 sky130_hd_ro41_nand_0.sky130_hd_inv_1_29.A sky130_hd_xor_block_2.XORB 5.1e-19
C320 sky130_hd_ro41_nand_0.sky130_hd_inv_1_12.Y sky130_hd_xor_block_1.XORB 3.16e-19
C321 VDPWR sky130_hd_ro41_nand_0.sky130_hd_inv_1_31.Y 0.477f
C322 sky130_hd_ro33_nand_0.sky130_hd_inv_1_29.Y sky130_hd_ro33_nand_0.sky130_hd_inv_1_28.Y 0.16f
C323 a_28256_2257# sky130_hd_div_by_2_1.CLK 0.00877f
C324 sky130_hd_div_by_2_0.Qb a_28123_1713# 6.46e-19
C325 sky130_hd_div_by_2_3.Qb a_28324_2813# 0.00253f
C326 a_27558_2979# a_28195_2557# 0.00464f
C327 VDPWR sky130_hd_ro41_nand_0.sky130_hd_inv_1_26.Y 0.435f
C328 a_27631_1674# sky130_hd_div_by_2_2.Qb 2.51e-22
C329 a_23839_35537# sky130_hd_dfxtp_1_1.Q 0.018f
C330 a_27631_3850# sky130_hd_div_by_2_3.Qb 0.00966f
C331 VDPWR sky130_hd_ro47_nand_0.sky130_hd_inv_1_11.A 0.435f
C332 sky130_hd_ro47_nand_0.sky130_hd_inv_1_7.A sky130_hd_xor_block_0.XORB 3.86e-19
C333 sky130_hd_xor_block_2.XORB sky130_hd_ro41_nand_0.sky130_hd_inv_1_24.Y 5.1e-19
C334 sky130_hd_ro32_nand_0.sky130_hd_inv_1_18.Y VDPWR 0.419f
C335 a_23186_31740# sky130_hd_xor_block_1.sky130_hd_xor2_1_0.B 8.18e-19
C336 a_28188_1565# a_28195_1469# 0.975f
C337 VDPWR sky130_hd_ro33_nand_0.sky130_hd_inv_1_22.Y 0.476f
C338 sky130_hd_ro47_nand_0.sky130_hd_inv_1_7.A sky130_hd_xor_block_1.XORB 6.56e-19
C339 a_21179_33268# sky130_hd_xor_block_2.sky130_hd_xor2_1_0.A 0.0956f
C340 a_28424_3247# a_28382_2979# 7.8e-20
C341 sky130_hd_ro41_nand_0.sky130_hd_inv_1_29.A sky130_hd_ro41_nand_0.sky130_hd_inv_1_28.Y 5.04e-19
C342 ui_in[4] ui_in[6] 6.02e-19
C343 sky130_hd_xor_block_2.XORB sky130_hd_ro41_nand_0.sky130_hd_inv_1_22.Y 5.1e-19
C344 sky130_hd_xor_block_3.XORA sky130_hd_ro33_nand_0.sky130_hd_inv_1_27.Y 9.74e-19
C345 sky130_hd_ro53_nand_0.sky130_hd_nand2_1_0.Y sky130_hd_xor_block_0.XORB 0.234f
C346 a_27999_2003# sky130_hd_div_by_2_1.CLK 0.00123f
C347 sky130_hd_ro47_nand_0.sky130_hd_inv_1_9.A sky130_hd_xor_block_0.XORB 3.86e-19
C348 sky130_hd_ro53_nand_0.sky130_hd_inv_1_3.Y sky130_hd_ro53_nand_0.sky130_hd_inv_1_1.Y 5.04e-19
C349 sky130_hd_xor_block_2.sky130_hd_xor2_1_0.A sky130_hd_xor_block_2.XOROUT 0.036f
C350 sky130_hd_xor_block_1.XORB sky130_hd_ro47_nand_0.sky130_hd_inv_1_9.A 6.56e-19
C351 VDPWR sky130_hd_ro47_nand_0.sky130_hd_inv_1_32.Y 0.475f
C352 a_2975_25393# ui_in[7] 1.64e-19
C353 a_27558_1891# a_27536_2409# 4.8e-19
C354 a_22016_35929# sky130_hd_inv_1_0.A 1.9e-19
C355 a_28571_2435# sky130_hd_div_by_2_2.Q 3.18e-19
C356 a_27631_2762# a_27999_3091# 7.11e-19
C357 a_28340_2257# sky130_hd_div_by_2_2.Q 1.65e-19
C358 a_27746_2979# VDPWR 0.0754f
C359 sky130_hd_ro37_nand_0.sky130_hd_inv_1_15.Y sky130_hd_ro37_nand_0.sky130_hd_inv_1_13.Y 5.04e-19
C360 sky130_hd_ro33_nand_0.sky130_hd_inv_1_13.Y sky130_hd_ro33_nand_0.sky130_hd_inv_1_12.Y 0.152f
C361 sky130_hd_ro47_nand_0.sky130_hd_inv_1_38.Y sky130_hd_xor_block_0.XORB 3.86e-19
C362 sky130_hd_ro37_nand_0.sky130_hd_inv_1_35.Y sky130_hd_ro37_nand_0.sky130_hd_inv_1_33.Y 5.04e-19
C363 a_22612_35563# a_22058_35537# 0.0622f
C364 sky130_hd_div_by_2_3.Q sky130_hd_div_by_2_2.Q 1.9e-19
C365 sky130_hd_ro47_nand_0.sky130_hd_inv_1_22.Y VDPWR 0.442f
C366 sky130_hd_ro33_nand_0.sky130_hd_inv_1_19.Y sky130_hd_ro33_nand_0.sky130_hd_inv_1_21.Y 5.04e-19
C367 a_27903_3755# a_27999_3091# 0.00205f
C368 sky130_hd_xor_block_1.XORB sky130_hd_ro41_nand_0.sky130_hd_inv_1_7.A 3.16e-19
C369 sky130_hd_ro47_nand_0.sky130_hd_inv_1_38.Y sky130_hd_xor_block_1.XORB 6.56e-19
C370 sky130_hd_ro47_nand_0.sky130_hd_inv_1_42.Y sky130_hd_ro47_nand_0.sky130_hd_inv_1_40.Y 5.04e-19
C371 a_27392_1891# a_28188_1565# 0.00247f
C372 sky130_hd_div_by_2_1.Qb a_27536_1321# 0.11f
C373 sky130_hd_div_by_2_0.Qb ua[1] 0.0111f
C374 a_21179_33268# VDPWR 0.255f
C375 sky130_hd_ro47_nand_0.sky130_hd_inv_1_18.Y sky130_hd_xor_block_0.XORB 3.86e-19
C376 VDPWR a_24081_35929# 0.00464f
C377 sky130_hd_ro37_nand_0.sky130_hd_inv_1_30.Y sky130_hd_ro37_nand_0.sky130_hd_inv_1_28.Y 5.04e-19
C378 sky130_hd_ro37_nand_0.sky130_hd_inv_1_30.Y sky130_hd_ro33_nand_0.sky130_hd_inv_1_31.Y 2.28e-19
C379 VDPWR sky130_hd_ro37_nand_0.sky130_hd_inv_1_22.Y 0.44f
C380 sky130_hd_ro53_nand_0.sky130_hd_inv_1_43.Y sky130_hd_ro53_nand_0.sky130_hd_inv_1_41.A 2.69e-19
C381 sky130_hd_xor_block_2.XORB sky130_hd_ro37_nand_0.sky130_hd_inv_1_25.Y 3.07e-19
C382 sky130_hd_ro47_nand_0.sky130_hd_inv_1_18.Y sky130_hd_xor_block_1.XORB 6.56e-19
C383 sky130_hd_div_by_2_0.Qb a_28855_2213# 0.11f
C384 ua[0] sky130_hd_ro32_nand_0.sky130_hd_nand2_1_0.Y 0.203f
C385 sky130_hd_div_by_2_1.CLK sky130_hd_div_by_2_2.Qb 0.0359f
C386 sky130_hd_xor_block_0.XORB sky130_hd_ro53_nand_0.sky130_hd_inv_1_21.A 7.87e-19
C387 sky130_hd_ro53_nand_0.sky130_hd_inv_1_47.Y sky130_hd_ro53_nand_0.sky130_hd_inv_1_49.Y 5.04e-19
C388 sky130_hd_div_by_2_1.Qb a_28256_2257# 0.00306f
C389 sky130_hd_ro37_nand_0.sky130_hd_inv_1_14.Y sky130_hd_ro37_nand_0.sky130_hd_inv_1_16.Y 5.04e-19
C390 sky130_hd_ro32_nand_0.sky130_hd_inv_1_11.Y ua[0] 0.011f
C391 sky130_hd_ro41_nand_0.sky130_hd_inv_1_15.Y sky130_hd_xor_block_1.XORB 3.16e-19
C392 VDPWR sky130_hd_xor_block_2.XOROUT 0.571f
C393 a_28424_2159# a_28855_2213# 0.108f
C394 sky130_hd_dfxtp_1_1.Q a_21774_35537# 8.57e-19
C395 a_28123_1713# a_28324_1725# 4.67e-20
C396 sky130_hd_ro37_nand_0.sky130_hd_inv_1_23.Y sky130_hd_ro41_nand_0.sky130_hd_inv_1_24.Y 6.22e-19
C397 sky130_hd_ro32_nand_0.sky130_hd_inv_1_27.Y sky130_hd_ro32_nand_0.sky130_hd_nand2_1_0.Y 2.03e-19
C398 VDPWR a_2975_25393# 1.7e-19
C399 sky130_hd_ro41_nand_0.sky130_hd_inv_1_34.Y sky130_hd_ro41_nand_0.sky130_hd_inv_1_33.Y 0.16f
C400 ui_in[3] sky130_hd_ro33_nand_0.sky130_hd_inv_1_31.Y 9.39e-20
C401 sky130_hd_ro47_nand_0.sky130_hd_inv_1_12.A sky130_hd_ro47_nand_0.sky130_hd_inv_1_13.A 0.16f
C402 sky130_hd_div_by_2_4.Q a_28571_3523# 3.18e-19
C403 sky130_hd_ro32_nand_0.sky130_hd_inv_1_26.Y sky130_hd_ro32_nand_0.sky130_hd_inv_1_25.Y 0.16f
C404 sky130_hd_xor_block_2.XORB sky130_hd_ro41_nand_0.sky130_hd_inv_1_21.Y 5.1e-19
C405 a_28855_2213# a_28195_2557# 4.8e-19
C406 a_27631_1674# a_27536_2409# 1.44e-21
C407 sky130_hd_xor_block_3.XORA sky130_hd_ro33_nand_0.sky130_hd_inv_1_8.Y 4.99e-19
C408 VDPWR a_28146_1347# 0.00464f
C409 ena sky130_hd_ro32_nand_0.sky130_hd_inv_1_15.Y 1.99e-19
C410 sky130_hd_ro47_nand_0.sky130_hd_inv_1_23.Y sky130_hd_ro47_nand_0.sky130_hd_inv_1_24.Y 0.16f
C411 sky130_hd_ro41_nand_0.sky130_hd_inv_1_5.A VDPWR 0.451f
C412 sky130_hd_ro37_nand_0.sky130_hd_inv_1_2.A sky130_hd_xor_block_3.XORB 7.98e-19
C413 sky130_hd_xor_block_0.sky130_hd_xor2_1_0.B a_24868_30833# 0.34f
C414 ua[0] a_28855_3301# 3.09e-19
C415 sky130_hd_ro37_nand_0.sky130_hd_inv_1_14.Y sky130_hd_ro41_nand_0.sky130_hd_inv_1_15.Y 6.22e-19
C416 a_27558_2979# a_27631_2762# 0.00175f
C417 uio_in[0] ui_in[7] 0.0351f
C418 sky130_hd_xor_block_2.XORB sky130_hd_ro41_nand_0.sky130_hd_inv_1_38.Y 0.00749f
C419 VDPWR sky130_hd_xor_block_0.XOROUT 0.45f
C420 a_28188_2653# a_28188_3741# 0.00114f
C421 sky130_hd_ro32_nand_0.sky130_hd_inv_1_28.Y ena 3.44e-19
C422 sky130_hd_ro32_nand_0.sky130_hd_inv_1_3.Y sky130_hd_ro32_nand_0.sky130_hd_inv_1_2.Y 0.16f
C423 a_28188_2653# a_28256_2257# 0.01f
C424 sky130_hd_div_by_2_1.Qb a_27999_2003# 0.00226f
C425 VDPWR sky130_hd_ro53_nand_0.sky130_hd_inv_1_44.Y 0.448f
C426 sky130_hd_xor_block_0.XORB sky130_hd_ro53_nand_0.sky130_hd_inv_1_20.A 7.87e-19
C427 sky130_hd_ro41_nand_0.sky130_hd_inv_1_31.Y sky130_hd_ro41_nand_0.sky130_hd_inv_1_32.Y 0.16f
C428 sky130_hd_ro53_nand_0.sky130_hd_inv_1_14.A sky130_hd_ro53_nand_0.sky130_hd_inv_1_16.A 2.69e-19
C429 sky130_hd_ro33_nand_0.sky130_hd_inv_1_23.Y sky130_hd_ro33_nand_0.sky130_hd_inv_1_22.Y 0.152f
C430 VDPWR sky130_hd_ro32_nand_0.sky130_hd_nand2_1_0.Y 0.423f
C431 sky130_hd_xor_block_3.sky130_hd_xor2_1_0.B sky130_hd_ro33_nand_0.sky130_hd_inv_1_1.Y 3.2e-20
C432 a_27558_2979# a_27903_3755# 8.74e-20
C433 sky130_hd_ro47_nand_0.sky130_hd_inv_1_39.Y sky130_hd_ro47_nand_0.sky130_hd_inv_1_40.Y 0.16f
C434 sky130_hd_ro37_nand_0.sky130_hd_inv_1_35.Y VDPWR 0.441f
C435 sky130_hd_ro32_nand_0.sky130_hd_inv_1_11.Y VDPWR 0.417f
C436 sky130_hd_ro53_nand_0.sky130_hd_inv_1_40.Y sky130_hd_ro53_nand_0.sky130_hd_inv_1_38.Y 5.04e-19
C437 a_27392_1891# a_27926_2257# 0.0027f
C438 a_28123_3889# a_27903_3755# 0.00617f
C439 a_28424_3247# sky130_hd_div_by_2_4.Qb 0.00664f
C440 VDPWR sky130_hd_xor_block_1.sky130_hd_xor2_1_0.B 0.535f
C441 sky130_hd_ro53_nand_0.sky130_hd_nand2_1_0.Y sky130_hd_ro53_nand_0.sky130_hd_inv_1_49.Y 6.18e-19
C442 a_28395_3800# sky130_hd_div_by_2_4.Qb 0.0121f
C443 sky130_hd_ro47_nand_0.sky130_hd_inv_1_5.Y sky130_hd_ro47_nand_0.sky130_hd_inv_1_4.Y 0.16f
C444 ua[0] a_28742_3901# 0.00145f
C445 sky130_hd_ro32_nand_0.sky130_hd_inv_1_3.Y ua[0] 0.0128f
C446 a_27999_2003# a_27903_2667# 0.00205f
C447 VDPWR a_24506_35929# 0.00292f
C448 VDPWR a_28855_3301# 0.21f
C449 a_28188_2653# a_27999_2003# 4.32e-20
C450 sky130_hd_div_by_2_4.Q a_28340_3345# 1.65e-19
C451 VDPWR sky130_hd_ro33_nand_0.sky130_hd_inv_1_26.Y 0.436f
C452 uio_in[3] uio_in[4] 0.031f
C453 sky130_hd_ro33_nand_0.sky130_hd_nand2_1_0.Y sky130_hd_ro33_nand_0.sky130_hd_inv_1_27.Y 2.03e-19
C454 a_28188_3741# a_27392_2979# 0.00154f
C455 a_24259_35563# a_24081_35929# 9.73e-19
C456 sky130_hd_ro37_nand_0.sky130_hd_inv_1_23.Y sky130_hd_ro37_nand_0.sky130_hd_inv_1_25.Y 5.04e-19
C457 VDPWR sky130_hd_ro37_nand_0.sky130_hd_inv_1_13.Y 0.438f
C458 sky130_hd_ro47_nand_0.sky130_hd_inv_1_25.Y sky130_hd_ro47_nand_0.sky130_hd_inv_1_26.Y 0.16f
C459 sky130_hd_div_by_2_1.CLK a_28395_2712# 0.00123f
C460 ua[1] a_28324_1725# 9.15e-19
C461 a_28256_2257# a_27392_2979# 1.62e-20
C462 ui_in[5] ui_in[3] 6.46e-19
C463 VDPWR sky130_hd_ro37_nand_0.sky130_hd_inv_1_6.A 0.444f
C464 a_27831_2257# a_27999_3091# 3.2e-20
C465 VDPWR sky130_hd_ro47_nand_0.sky130_hd_inv_1_19.Y 0.501f
C466 sky130_hd_ro41_nand_0.sky130_hd_inv_1_36.Y sky130_hd_ro37_nand_0.sky130_hd_inv_1_35.Y 6.22e-19
C467 sky130_hd_ro53_nand_0.sky130_hd_inv_1_32.Y sky130_hd_ro53_nand_0.sky130_hd_inv_1_31.Y 0.16f
C468 VDPWR a_28742_3901# 0.0754f
C469 sky130_hd_ro47_nand_0.sky130_hd_inv_1_22.Y sky130_hd_ro47_nand_0.sky130_hd_inv_1_21.Y 0.16f
C470 sky130_hd_ro32_nand_0.sky130_hd_inv_1_3.Y VDPWR 0.416f
C471 sky130_hd_ro37_nand_0.sky130_hd_inv_1_12.Y sky130_hd_ro37_nand_0.sky130_hd_inv_1_13.Y 0.16f
C472 sky130_hd_ro32_nand_0.sky130_hd_inv_1_17.Y sky130_hd_ro32_nand_0.sky130_hd_inv_1_19.Y 5.04e-19
C473 a_27903_1579# a_28146_1347# 0.00851f
C474 a_24058_35563# VDPWR 4.56e-19
C475 sky130_hd_ro47_nand_0.sky130_hd_inv_1_34.Y VDPWR 0.463f
C476 sky130_hd_ro41_nand_0.sky130_hd_inv_1_2.A sky130_hd_xor_block_2.XORB 5.1e-19
C477 sky130_hd_xor_block_1.XORB sky130_hd_ro41_nand_0.sky130_hd_inv_1_9.A 3.16e-19
C478 VDPWR sky130_hd_ro47_nand_0.sky130_hd_inv_1_8.A 0.446f
C479 VDPWR a_28395_1624# 0.247f
C480 VDPWR sky130_hd_ro41_nand_0.sky130_hd_inv_1_30.Y 0.485f
C481 sky130_hd_ro41_nand_0.sky130_hd_inv_1_6.A VDPWR 0.48f
C482 sky130_hd_ro53_nand_0.sky130_hd_inv_1_2.Y VDPWR 0.447f
C483 a_24259_35563# sky130_hd_xor_block_0.XOROUT 0.00295f
C484 sky130_hd_ro53_nand_0.sky130_hd_inv_1_48.Y ui_in[7] 1.57e-19
C485 a_27903_2667# sky130_hd_div_by_2_2.Qb 0.028f
C486 a_21993_35563# a_21774_35537# 0.00617f
C487 a_21261_33268# sky130_hd_xor_block_2.sky130_hd_xor2_1_0.B 0.014f
C488 a_28195_3645# sky130_hd_div_by_2_4.Qb 0.265f
C489 a_28195_3645# a_27536_3497# 2.25e-19
C490 sky130_hd_ro53_nand_0.sky130_hd_inv_1_19.A sky130_hd_ro53_nand_0.sky130_hd_inv_1_21.A 5.04e-19
C491 sky130_hd_xor_block_3.XORA a_19445_33932# 0.00131f
C492 sky130_hd_ro41_nand_0.sky130_hd_inv_1_6.A sky130_hd_ro41_nand_0.sky130_hd_inv_1_8.A 5.04e-19
C493 sky130_hd_ro53_nand_0.sky130_hd_inv_1_11.Y sky130_hd_ro53_nand_0.sky130_hd_inv_1_9.Y 5.04e-19
C494 sky130_hd_ro37_nand_0.sky130_hd_inv_1_30.Y sky130_hd_ro37_nand_0.sky130_hd_nand2_1_0.Y 5.97e-20
C495 a_28188_2653# sky130_hd_div_by_2_2.Qb 0.12f
C496 sky130_hd_ro47_nand_0.sky130_hd_inv_1_35.Y sky130_hd_ro47_nand_0.sky130_hd_inv_1_33.Y 5.04e-19
C497 ua[1] a_27631_2762# 4.17e-20
C498 VDPWR sky130_hd_xor_block_0.sky130_hd_inv_1_3.A 0.463f
C499 sky130_hd_xor_block_3.XORB sky130_hd_ro37_nand_0.sky130_hd_inv_1_8.Y 4.75e-19
C500 sky130_hd_xor_block_3.XORB sky130_hd_ro33_nand_0.sky130_hd_inv_1_21.Y 3.26e-19
C501 VDPWR sky130_hd_ro41_nand_0.sky130_hd_inv_1_25.Y 0.436f
C502 VDPWR a_27999_3091# 0.184f
C503 sky130_hd_xor_block_3.XORB sky130_hd_ro37_nand_0.sky130_hd_inv_1_29.Y 4.75e-19
C504 sky130_hd_ro32_nand_0.sky130_hd_inv_1_6.Y sky130_hd_ro32_nand_0.sky130_hd_inv_1_5.Y 0.16f
C505 sky130_hd_ro37_nand_0.sky130_hd_inv_1_11.Y sky130_hd_ro37_nand_0.sky130_hd_inv_1_13.Y 5.04e-19
C506 VDPWR sky130_hd_ro47_nand_0.sky130_hd_inv_1_28.Y 0.44f
C507 sky130_hd_ro41_nand_0.sky130_hd_inv_1_13.Y sky130_hd_ro41_nand_0.sky130_hd_inv_1_14.Y 0.16f
C508 a_6379_29870# VDPWR 1.7e-19
C509 sky130_hd_xor_block_3.XORA sky130_hd_ro33_nand_0.sky130_hd_inv_1_7.Y 6.68e-19
C510 a_27831_2257# a_27957_1891# 0.00553f
C511 clk a_22441_35929# 2.28e-19
C512 a_28324_3901# a_28742_3901# 3.39e-19
C513 sky130_hd_xor_block_3.XORB sky130_hd_ro33_nand_0.sky130_hd_inv_1_13.Y 3.26e-19
C514 sky130_hd_ro53_nand_0.sky130_hd_inv_1_35.Y sky130_hd_ro53_nand_0.sky130_hd_inv_1_33.Y 5.04e-19
C515 a_27831_2257# a_27558_2979# 8.17e-21
C516 a_27926_3345# sky130_hd_div_by_2_3.Qb 7.17e-19
C517 sky130_hd_ro53_nand_0.sky130_hd_inv_1_19.A sky130_hd_ro53_nand_0.sky130_hd_inv_1_20.A 0.16f
C518 VDPWR a_22065_35837# 0.299f
C519 a_27558_2979# ua[0] 1.65e-21
C520 sky130_hd_ro47_nand_0.sky130_hd_inv_1_41.Y sky130_hd_ro47_nand_0.sky130_hd_inv_1_40.Y 0.16f
C521 a_28424_2159# a_28256_3345# 8.53e-20
C522 sky130_hd_ro53_nand_0.sky130_hd_inv_1_41.Y sky130_hd_ro53_nand_0.sky130_hd_inv_1_42.Y 5.04e-19
C523 sky130_hd_xor_block_0.sky130_hd_xor2_1_0.B a_25118_30833# 0.057f
C524 VDPWR sky130_hd_ro53_nand_0.sky130_hd_inv_1_29.Y 0.439f
C525 sky130_hd_ro47_nand_0.sky130_hd_inv_1_18.Y sky130_hd_ro47_nand_0.sky130_hd_inv_1_20.Y 5.04e-19
C526 VDPWR sky130_hd_ro53_nand_0.sky130_hd_inv_1_48.Y 0.442f
C527 a_23186_31740# sky130_hd_xor_block_1.XOROUT 0.00242f
C528 sky130_hd_div_by_2_2.Qb a_27392_2979# 0.00279f
C529 sky130_hd_div_by_2_0.Qb a_28424_2159# 0.0478f
C530 sky130_hd_ro32_nand_0.sky130_hd_inv_1_7.Y ua[0] 0.011f
C531 a_28256_3345# a_28195_2557# 0.00597f
C532 sky130_hd_ro33_nand_0.sky130_hd_nand2_1_0.Y sky130_hd_ro37_nand_0.sky130_hd_inv_1_31.Y 2.28e-19
C533 a_22194_35563# a_22065_35837# 0.127f
C534 a_27558_1891# a_28188_1565# 0.00101f
C535 ui_in[4] ui_in[3] 4.38f
C536 sky130_hd_xor_block_3.XORB sky130_hd_ro33_nand_0.sky130_hd_inv_1_25.Y 3.26e-19
C537 sky130_hd_div_by_2_0.Qb a_28195_2557# 0.00222f
C538 sky130_hd_xor_block_2.XORB sky130_hd_ro41_nand_0.sky130_hd_inv_1_14.Y 5.1e-19
C539 sky130_hd_xor_block_3.XOROUT sky130_hd_xor_block_3.sky130_hd_xor2_1_0.A 0.0363f
C540 sky130_hd_div_by_2_1.Qb a_27536_2409# 1.74e-20
C541 sky130_hd_ro41_nand_0.sky130_hd_inv_1_16.Y sky130_hd_ro37_nand_0.sky130_hd_inv_1_15.Y 6.22e-19
C542 a_28424_2159# a_28195_2557# 0.00702f
C543 a_24259_35563# a_24058_35563# 4.67e-20
C544 a_22612_35563# a_22265_35537# 0.0373f
C545 VDPWR a_27558_2979# 0.299f
C546 sky130_hd_ro53_nand_0.sky130_hd_inv_1_50.Y sky130_hd_xor_block_0.XORB 0.00787f
C547 VDPWR a_28123_3889# 4.56e-19
C548 sky130_hd_ro47_nand_0.sky130_hd_inv_1_21.Y sky130_hd_ro47_nand_0.sky130_hd_inv_1_19.Y 5.04e-19
C549 sky130_hd_ro41_nand_0.sky130_hd_inv_1_5.A sky130_hd_ro41_nand_0.sky130_hd_inv_1_3.A 5.04e-19
C550 a_28188_2653# a_28395_2712# 0.273f
C551 sky130_hd_xor_block_3.sky130_hd_inv_1_1.Y VDPWR 0.463f
C552 VDPWR sky130_hd_ro32_nand_0.sky130_hd_inv_1_7.Y 0.417f
C553 VDPWR a_28123_1713# 4.56e-19
C554 a_28188_2653# a_27536_2409# 1.73e-20
C555 sky130_hd_ro41_nand_0.sky130_hd_inv_1_29.A sky130_hd_xor_block_1.XORB 3.16e-19
C556 sky130_hd_ro41_nand_0.sky130_hd_inv_1_21.Y sky130_hd_ro41_nand_0.sky130_hd_inv_1_19.Y 5.04e-19
C557 a_28188_3741# sky130_hd_div_by_2_3.Q 0.00808f
C558 a_28340_2257# a_28256_2257# 0.00851f
C559 sky130_hd_ro32_nand_0.sky130_hd_inv_1_26.Y sky130_hd_ro32_nand_0.sky130_hd_nand2_1_0.Y 5.97e-20
C560 VDPWR a_8679_33959# 3.68e-19
C561 clk a_23839_35537# 0.012f
C562 sky130_hd_ro53_nand_0.sky130_hd_inv_1_2.Y sky130_hd_ro53_nand_0.sky130_hd_inv_1_4.Y 5.04e-19
C563 sky130_hd_ro47_nand_0.sky130_hd_inv_1_43.Y sky130_hd_ro47_nand_0.sky130_hd_inv_1_45.Y 5.04e-19
C564 a_22612_35563# a_24123_35537# 1.66e-21
C565 sky130_hd_ro41_nand_0.sky130_hd_inv_1_30.Y sky130_hd_ro41_nand_0.sky130_hd_inv_1_32.Y 5.04e-19
C566 sky130_hd_ro41_nand_0.sky130_hd_inv_1_29.Y sky130_hd_ro41_nand_0.sky130_hd_inv_1_30.Y 5.04e-19
C567 sky130_hd_ro41_nand_0.sky130_hd_inv_1_24.Y sky130_hd_xor_block_1.XORB 3.16e-19
C568 sky130_hd_ro37_nand_0.sky130_hd_inv_1_30.Y sky130_hd_xor_block_3.XORB 4.75e-19
C569 sky130_hd_ro41_nand_0.sky130_hd_inv_1_29.A sky130_hd_ro37_nand_0.sky130_hd_inv_1_28.Y 2.28e-19
C570 a_27631_1674# a_28188_1565# 0.0486f
C571 sky130_hd_ro33_nand_0.sky130_hd_inv_1_27.Y sky130_hd_ro33_nand_0.sky130_hd_inv_1_28.Y 0.16f
C572 sky130_hd_ro32_nand_0.sky130_hd_inv_1_10.Y ena 1.99e-19
C573 sky130_hd_xor_block_3.XORA sky130_hd_ro33_nand_0.sky130_hd_inv_1_2.Y 0.00982f
C574 sky130_hd_div_by_2_3.Qb a_27903_2667# 0.00317f
C575 sky130_hd_tapvpwrvgnd_1_7.VPWR ua[0] 0.00214f
C576 sky130_hd_ro32_nand_0.sky130_hd_inv_1_16.Y ua[0] 0.011f
C577 sky130_hd_ro32_nand_0.sky130_hd_inv_1_30.Y sky130_hd_ro32_nand_0.sky130_hd_inv_1_31.Y 0.16f
C578 a_28382_1891# sky130_hd_div_by_2_1.CLK 1.28e-19
C579 a_28340_2257# a_27999_2003# 9.73e-19
C580 sky130_hd_ro37_nand_0.sky130_hd_inv_1_17.Y sky130_hd_ro37_nand_0.sky130_hd_inv_1_15.Y 5.04e-19
C581 sky130_hd_ro47_nand_0.sky130_hd_inv_1_37.Y sky130_hd_xor_block_0.XORB 3.86e-19
C582 a_28324_3901# a_27558_2979# 8.84e-20
C583 sky130_hd_xor_block_1.XORB sky130_hd_ro47_nand_0.sky130_hd_inv_1_37.Y 6.56e-19
C584 VDPWR sky130_hd_ro53_nand_0.sky130_hd_inv_1_25.Y 0.436f
C585 a_28188_2653# sky130_hd_div_by_2_3.Qb 0.00264f
C586 sky130_hd_div_by_2_0.Qb a_28324_1725# 0.00271f
C587 a_28324_3901# a_28123_3889# 4.67e-20
C588 a_27831_3345# a_27631_2762# 0.00305f
C589 sky130_hd_xor_block_3.XORB sky130_hd_ro37_nand_0.sky130_hd_inv_1_16.Y 4.75e-19
C590 sky130_hd_xor_block_1.XORB sky130_hd_ro41_nand_0.sky130_hd_inv_1_22.Y 3.16e-19
C591 ui_in[3] sky130_hd_xor_block_3.XORB 0.00666f
C592 a_28855_2213# ua[0] 3.03e-19
C593 a_27392_2979# a_27536_2409# 0.0084f
C594 a_28424_2159# a_28324_1725# 7.11e-19
C595 sky130_hd_ro32_nand_0.sky130_hd_inv_1_13.Y sky130_hd_ro32_nand_0.sky130_hd_inv_1_15.Y 5.04e-19
C596 a_27831_3345# a_27903_3755# 0.00138f
C597 a_27631_3850# sky130_hd_div_by_2_4.Qb 0.0303f
C598 a_27631_3850# a_27536_3497# 0.108f
C599 sky130_hd_xor_block_2.sky130_hd_inv_1_3.A sky130_hd_xor_block_2.sky130_hd_xor2_1_0.A 0.00398f
C600 sky130_hd_xor_block_0.XOROUT a_24330_35537# 0.0031f
C601 sky130_hd_ro32_nand_0.sky130_hd_inv_1_19.Y ena 1.99e-19
C602 VDPWR sky130_hd_ro41_nand_0.sky130_hd_inv_1_35.Y 0.442f
C603 sky130_hd_ro47_nand_0.sky130_hd_inv_1_1.Y sky130_hd_xor_block_0.XORB 6.93e-19
C604 a_22936_31990# a_23186_31990# 0.0244f
C605 a_28195_2557# a_28324_1725# 8.47e-22
C606 VDPWR sky130_hd_ro41_nand_0.sky130_hd_inv_1_4.A 0.445f
C607 VDPWR sky130_hd_ro32_nand_0.sky130_hd_inv_1_16.Y 0.42f
C608 sky130_hd_ro47_nand_0.sky130_hd_inv_1_1.Y sky130_hd_xor_block_1.XORB 0.161f
C609 VDPWR sky130_hd_xor_block_1.XOROUT 0.519f
C610 VDPWR sky130_hd_tapvpwrvgnd_1_7.VPWR 0.00693f
C611 sky130_hd_ro37_nand_0.sky130_hd_inv_1_2.A sky130_hd_ro37_nand_0.sky130_hd_inv_1_8.Y 2.69e-19
C612 sky130_hd_ro53_nand_0.sky130_hd_inv_1_3.Y sky130_hd_xor_block_0.XORB 0.00355f
C613 VDPWR ua[1] 0.716f
C614 sky130_hd_xor_block_2.XORB sky130_hd_ro41_nand_0.sky130_hd_inv_1_17.Y 5.1e-19
C615 sky130_hd_div_by_2_0.Qb a_27631_2762# 0.00865f
C616 VDPWR a_28855_2213# 0.21f
C617 VDPWR sky130_hd_ro41_nand_0.sky130_hd_inv_1_16.Y 0.442f
C618 sky130_hd_ro37_nand_0.sky130_hd_inv_1_25.A sky130_hd_ro33_nand_0.sky130_hd_inv_1_26.Y 6.23e-19
C619 sky130_hd_div_by_2_3.Qb a_27392_2979# 0.12f
C620 a_28571_2435# sky130_hd_div_by_2_2.Qb 7.05e-19
C621 a_28146_1347# a_28195_1469# 6.32e-19
C622 sky130_hd_ro53_nand_0.sky130_hd_inv_1_50.Y sky130_hd_ro53_nand_0.sky130_hd_inv_1_49.Y 0.16f
C623 a_24330_35537# a_24506_35929# 0.00772f
C624 a_28340_2257# sky130_hd_div_by_2_2.Qb 4.93e-19
C625 sky130_hd_div_by_2_2.Qb a_27957_2979# 9.31e-19
C626 clk a_21774_35537# 0.0013f
C627 a_27903_1579# a_28123_1713# 0.00617f
C628 a_28424_3247# a_28855_3301# 0.108f
C629 a_28195_2557# a_27631_2762# 0.0341f
C630 sky130_hd_div_by_2_3.Q sky130_hd_div_by_2_2.Qb 0.139f
C631 VDPWR sky130_hd_ro47_nand_0.sky130_hd_inv_1_30.Y 0.443f
C632 a_27926_2257# a_27746_1891# 0.00123f
C633 sky130_hd_ro33_nand_0.sky130_hd_inv_1_3.Y sky130_hd_ro37_nand_0.sky130_hd_inv_1_5.A 2.28e-19
C634 a_28188_1565# sky130_hd_div_by_2_1.CLK 0.292f
C635 sky130_hd_ro53_nand_0.sky130_hd_inv_1_43.Y sky130_hd_xor_block_0.XORB 7.87e-19
C636 sky130_hd_ro32_nand_0.sky130_hd_inv_1_16.Y sky130_hd_ro32_nand_0.sky130_hd_inv_1_14.Y 5.04e-19
C637 sky130_hd_ro41_nand_0.sky130_hd_inv_1_2.A sky130_hd_ro37_nand_0.sky130_hd_inv_1_9.Y 2.28e-19
C638 sky130_hd_ro41_nand_0.sky130_hd_inv_1_36.Y sky130_hd_ro41_nand_0.sky130_hd_inv_1_35.Y 0.16f
C639 VDPWR sky130_hd_xor_block_2.sky130_hd_inv_1_3.A 0.468f
C640 a_28424_3247# a_28742_3901# 4.18e-19
C641 sky130_hd_xor_block_1.XORB sky130_hd_ro41_nand_0.sky130_hd_inv_1_21.Y 3.16e-19
C642 sky130_hd_ro47_nand_0.sky130_hd_inv_1_29.Y sky130_hd_ro47_nand_0.sky130_hd_inv_1_28.Y 0.16f
C643 a_28742_3901# a_28395_3800# 0.0373f
C644 sky130_hd_xor_block_0.sky130_hd_inv_1_3.A sky130_hd_xor_block_0.sky130_hd_inv_1_1.Y 0.0274f
C645 sky130_hd_xor_block_2.XORB sky130_hd_xor_block_2.sky130_hd_inv_1_1.Y 0.161f
C646 VDPWR sky130_hd_ro53_nand_0.sky130_hd_inv_1_41.Y 0.435f
C647 a_28571_3523# a_28188_3741# 0.0027f
C648 sky130_hd_div_by_2_3.Qb a_28146_3523# 5.03e-19
C649 sky130_hd_ro53_nand_0.sky130_hd_inv_1_22.A sky130_hd_ro53_nand_0.sky130_hd_inv_1_22.Y 0.16f
C650 sky130_hd_xor_block_1.XORB sky130_hd_ro41_nand_0.sky130_hd_inv_1_38.Y 0.00181f
C651 sky130_hd_ro53_nand_0.sky130_hd_inv_1_32.Y sky130_hd_ro53_nand_0.sky130_hd_inv_1_33.Y 0.157f
C652 sky130_hd_div_by_2_1.Qb a_28382_1891# 6.08e-19
C653 sky130_hd_ro32_nand_0.sky130_hd_inv_1_9.Y ena 1.99e-19
C654 sky130_hd_ro47_nand_0.sky130_hd_inv_1_2.Y sky130_hd_xor_block_0.XORB 3.86e-19
C655 sky130_hd_xor_block_3.XORA sky130_hd_ro33_nand_0.sky130_hd_inv_1_20.Y 4.99e-19
C656 a_22016_35929# VDPWR 0.00464f
C657 sky130_hd_ro47_nand_0.sky130_hd_inv_1_2.Y sky130_hd_xor_block_1.XORB 0.00604f
C658 sky130_hd_ro47_nand_0.sky130_hd_inv_1_5.Y VDPWR 0.464f
C659 sky130_hd_ro53_nand_0.sky130_hd_inv_1_32.Y sky130_hd_ro53_nand_0.sky130_hd_inv_1_30.Y 5.04e-19
C660 sky130_hd_ro53_nand_0.sky130_hd_inv_1_45.Y VDPWR 0.466f
C661 sky130_hd_ro37_nand_0.sky130_hd_inv_1_17.Y VDPWR 0.518f
C662 sky130_hd_ro33_nand_0.sky130_hd_inv_1_5.Y VDPWR 0.464f
C663 sky130_hd_ro32_nand_0.sky130_hd_inv_1_2.Y a_27831_3345# 3.18e-21
C664 sky130_hd_ro32_nand_0.sky130_hd_inv_1_30.Y sky130_hd_ro32_nand_0.sky130_hd_inv_1_29.Y 0.16f
C665 a_27926_2257# sky130_hd_div_by_2_1.CLK 2.47e-19
C666 sky130_hd_ro41_nand_0.sky130_hd_inv_1_16.Y sky130_hd_ro41_nand_0.sky130_hd_inv_1_18.Y 5.04e-19
C667 sky130_hd_ro33_nand_0.sky130_hd_inv_1_6.Y sky130_hd_xor_block_3.XORB 3.26e-19
C668 sky130_hd_inv_1_0.A VDPWR 0.453f
C669 sky130_hd_ro33_nand_0.sky130_hd_inv_1_19.Y sky130_hd_ro33_nand_0.sky130_hd_inv_1_17.Y 5.04e-19
C670 a_22194_35563# a_22016_35929# 9.73e-19
C671 a_28195_3645# a_28855_3301# 4.8e-19
C672 sky130_hd_xor_block_3.XORA sky130_hd_ro33_nand_0.sky130_hd_inv_1_10.Y 4.99e-19
C673 a_28424_3247# a_27999_3091# 1.28e-19
C674 a_27831_2257# a_27831_3345# 6.62e-19
C675 sky130_hd_ro32_nand_0.sky130_hd_nand2_1_0.Y sky130_hd_ro32_nand_0.sky130_hd_inv_1_31.Y 0.172f
C676 a_27903_1579# ua[1] 0.00803f
C677 sky130_hd_ro53_nand_0.sky130_hd_inv_1_18.A sky130_hd_ro53_nand_0.sky130_hd_inv_1_20.A 5.04e-19
C678 sky130_hd_ro53_nand_0.sky130_hd_inv_1_11.Y sky130_hd_xor_block_0.XORB 7.87e-19
C679 sky130_hd_ro53_nand_0.sky130_hd_inv_1_15.A sky130_hd_ro53_nand_0.sky130_hd_inv_1_13.A 5.04e-19
C680 a_28571_2435# a_28395_2712# 0.00772f
C681 a_28395_1624# a_28195_1469# 0.083f
C682 sky130_hd_ro41_nand_0.sky130_hd_inv_1_1.A sky130_hd_ro37_nand_0.sky130_hd_inv_1_10.Y 2.28e-19
C683 VDPWR sky130_hd_ro33_nand_0.sky130_hd_inv_1_30.Y 0.447f
C684 a_22194_35563# sky130_hd_inv_1_0.A 0.00353f
C685 a_28195_3645# a_28742_3901# 0.0982f
C686 a_21179_33268# a_21429_33268# 0.0244f
C687 sky130_hd_div_by_2_3.Q a_28395_2712# 0.00111f
C688 sky130_hd_xor_block_3.XORB sky130_hd_ro37_nand_0.sky130_hd_inv_1_24.Y 4.75e-19
C689 a_28742_2813# sky130_hd_div_by_2_2.Q 2.87e-19
C690 sky130_hd_div_by_2_1.Qb a_28188_1565# 0.12f
C691 sky130_hd_ro53_nand_0.sky130_hd_inv_1_35.Y sky130_hd_ro53_nand_0.sky130_hd_inv_1_36.Y 0.16f
C692 sky130_hd_ro47_nand_0.sky130_hd_nand2_1_0.Y ui_in[7] 1.4e-23
C693 sky130_hd_xor_block_0.XOROUT a_24677_35563# 0.125f
C694 sky130_hd_div_by_2_3.Q a_27536_2409# 2.59e-19
C695 a_21429_33268# sky130_hd_xor_block_2.XOROUT 0.0712f
C696 sky130_hd_div_by_2_0.Qb a_27831_2257# 0.0222f
C697 sky130_hd_ro41_nand_0.sky130_hd_inv_1_2.A sky130_hd_xor_block_1.XORB 3.16e-19
C698 sky130_hd_ro41_nand_0.sky130_hd_inv_1_20.Y VDPWR 0.473f
C699 sky130_hd_div_by_2_0.Qb ua[0] 4.92e-19
C700 sky130_hd_xor_block_0.XOROUT sky130_hd_xor_block_0.sky130_hd_xor2_1_0.A 0.04f
C701 VDPWR a_27831_3345# 0.249f
C702 sky130_hd_ro53_nand_0.sky130_hd_inv_1_35.Y sky130_hd_xor_block_0.XORB 7.87e-19
C703 a_28424_2159# ua[0] 1.59e-19
C704 a_27631_2762# a_27903_3755# 3.92e-20
C705 sky130_hd_div_by_2_3.Qb a_27957_2979# 0.00167f
C706 sky130_hd_ro37_nand_0.sky130_hd_inv_1_17.Y sky130_hd_ro41_nand_0.sky130_hd_inv_1_18.Y 6.22e-19
C707 a_28188_1565# a_27903_2667# 1.62e-20
C708 a_27631_3850# a_27746_2979# 4.18e-19
C709 a_28424_3247# a_27558_2979# 0.0341f
C710 a_28188_2653# a_28188_1565# 0.00114f
C711 a_19445_33932# a_19695_33932# 0.0244f
C712 sky130_hd_xor_block_3.XORA sky130_hd_xor_block_3.XOROUT 5.39e-19
C713 ui_in[5] sky130_hd_ro41_nand_0.sky130_hd_inv_1_38.Y 5.12e-20
C714 sky130_hd_ro37_nand_0.sky130_hd_inv_1_4.A sky130_hd_ro33_nand_0.sky130_hd_inv_1_4.Y 2.28e-19
C715 sky130_hd_div_by_2_3.Qb sky130_hd_div_by_2_3.Q 0.178f
C716 a_28195_3645# a_27999_3091# 8.84e-20
C717 ua[0] a_28195_2557# 2.92e-19
C718 a_24677_35563# a_24506_35929# 0.00123f
C719 sky130_hd_xor_block_3.XORB sky130_hd_xor_block_3.sky130_hd_xor2_1_0.A 0.012f
C720 sky130_hd_ro37_nand_0.sky130_hd_inv_1_27.Y sky130_hd_ro33_nand_0.sky130_hd_inv_1_28.Y 2.28e-19
C721 sky130_hd_xor_block_0.XORB sky130_hd_ro47_nand_0.sky130_hd_inv_1_33.Y 3.86e-19
C722 sky130_hd_ro53_nand_0.sky130_hd_inv_1_34.Y VDPWR 0.466f
C723 a_19445_33932# a_19695_33682# 0.00723f
C724 sky130_hd_ro32_nand_0.sky130_hd_inv_1_2.Y sky130_hd_ro32_nand_0.sky130_hd_inv_1_4.Y 5.04e-19
C725 sky130_hd_ro53_nand_0.sky130_hd_inv_1_22.A sky130_hd_ro53_nand_0.sky130_hd_inv_1_21.A 0.16f
C726 sky130_hd_xor_block_1.XORB sky130_hd_ro47_nand_0.sky130_hd_inv_1_33.Y 6.56e-19
C727 sky130_hd_ro53_nand_0.sky130_hd_inv_1_40.Y sky130_hd_ro53_nand_0.sky130_hd_inv_1_41.A 5.04e-19
C728 VDPWR a_28256_3345# 0.187f
C729 sky130_hd_xor_block_0.XOROUT a_24950_30833# 4.42e-19
C730 sky130_hd_xor_block_3.XORA sky130_hd_ro33_nand_0.sky130_hd_inv_1_31.Y 0.0103f
C731 sky130_hd_div_by_2_0.Qb VDPWR 0.402f
C732 VDPWR sky130_hd_ro47_nand_0.sky130_hd_inv_1_4.Y 0.504f
C733 sky130_hd_ro47_nand_0.sky130_hd_nand2_1_0.Y VDPWR 0.415f
C734 sky130_hd_ro41_nand_0.sky130_hd_inv_1_4.A sky130_hd_ro41_nand_0.sky130_hd_inv_1_3.A 0.157f
C735 sky130_hd_ro47_nand_0.sky130_hd_inv_1_14.A sky130_hd_xor_block_0.XORB 3.86e-19
C736 a_27392_1891# a_27999_3091# 5.37e-21
C737 a_28424_2159# VDPWR 0.523f
C738 sky130_hd_ro47_nand_0.sky130_hd_inv_1_5.Y sky130_hd_ro47_nand_0.sky130_hd_inv_1_16.A 5.04e-19
C739 sky130_hd_div_by_2_4.Q sky130_hd_div_by_2_2.Q 0.00395f
C740 sky130_hd_ro33_nand_0.sky130_hd_inv_1_15.Y sky130_hd_xor_block_3.XORB 3.26e-19
C741 sky130_hd_ro47_nand_0.sky130_hd_inv_1_14.A sky130_hd_xor_block_1.XORB 6.56e-19
C742 ua[0] sky130_hd_ro32_nand_0.sky130_hd_inv_1_4.Y 0.0121f
C743 sky130_hd_ro41_nand_0.sky130_hd_nand2_1_0.Y sky130_hd_ro41_nand_0.sky130_hd_inv_1_38.Y 0.0021f
C744 sky130_hd_ro53_nand_0.sky130_hd_inv_1_14.A sky130_hd_ro53_nand_0.sky130_hd_inv_1_15.A 0.152f
C745 a_28324_3901# a_28544_3889# 4.62e-19
C746 VDPWR a_28195_2557# 0.299f
C747 sky130_hd_ro47_nand_0.sky130_hd_inv_1_45.Y sky130_hd_ro47_nand_0.sky130_hd_inv_1_44.Y 0.16f
C748 a_4631_27642# sky130_hd_xor_block_0.XORB 4.69e-20
C749 VDPWR sky130_hd_ro53_nand_0.sky130_hd_inv_1_5.Y 0.517f
C750 a_19445_33932# sky130_hd_xor_block_3.sky130_hd_inv_1_3.A 0.00265f
C751 a_27926_3345# sky130_hd_div_by_2_4.Qb 2.58e-19
C752 rst_n clk 0.0393f
C753 sky130_hd_xor_block_0.sky130_hd_inv_1_1.Y sky130_hd_xor_block_1.XOROUT 5.97e-19
C754 sky130_hd_ro41_nand_0.sky130_hd_inv_1_17.Y sky130_hd_ro41_nand_0.sky130_hd_inv_1_19.Y 5.04e-19
C755 sky130_hd_ro53_nand_0.sky130_hd_inv_1_22.A sky130_hd_ro53_nand_0.sky130_hd_inv_1_20.A 5.04e-19
C756 a_7207_31915# VDPWR 2.05e-19
C757 sky130_hd_xor_block_1.XORB sky130_hd_ro41_nand_0.sky130_hd_inv_1_14.Y 3.16e-19
C758 sky130_hd_ro37_nand_0.sky130_hd_inv_1_6.A sky130_hd_ro37_nand_0.sky130_hd_inv_1_5.A 0.16f
C759 sky130_hd_ro41_nand_0.sky130_hd_inv_1_20.Y sky130_hd_ro41_nand_0.sky130_hd_inv_1_18.Y 5.04e-19
C760 sky130_hd_ro33_nand_0.sky130_hd_inv_1_30.Y sky130_hd_ro33_nand_0.sky130_hd_inv_1_29.Y 0.16f
C761 sky130_hd_ro32_nand_0.sky130_hd_inv_1_29.Y sky130_hd_ro32_nand_0.sky130_hd_nand2_1_0.Y 6.18e-19
C762 sky130_hd_ro37_nand_0.sky130_hd_inv_1_30.Y sky130_hd_ro37_nand_0.sky130_hd_inv_1_29.Y 0.16f
C763 sky130_hd_ro53_nand_0.sky130_hd_inv_1_46.Y sky130_hd_ro53_nand_0.sky130_hd_inv_1_44.Y 5.04e-19
C764 sky130_hd_ro32_nand_0.sky130_hd_inv_1_30.Y sky130_hd_ro32_nand_0.sky130_hd_inv_1_28.Y 5.04e-19
C765 a_28195_3645# a_27558_2979# 6.13e-20
C766 a_28324_3901# a_28256_3345# 0.00205f
C767 sky130_hd_ro47_nand_0.sky130_hd_inv_1_29.Y sky130_hd_ro47_nand_0.sky130_hd_inv_1_30.Y 0.16f
C768 sky130_hd_ro53_nand_0.sky130_hd_inv_1_40.Y sky130_hd_ro53_nand_0.sky130_hd_inv_1_39.Y 0.16f
C769 sky130_hd_ro41_nand_0.sky130_hd_inv_1_21.Y sky130_hd_ro37_nand_0.sky130_hd_inv_1_20.Y 2.28e-19
C770 VDPWR sky130_hd_ro32_nand_0.sky130_hd_inv_1_4.Y 0.417f
C771 a_22612_35563# sky130_hd_dfxtp_1_1.Q 0.126f
C772 sky130_hd_ro33_nand_0.sky130_hd_inv_1_26.Y sky130_hd_ro33_nand_0.sky130_hd_inv_1_27.Y 0.16f
C773 sky130_hd_ro32_nand_0.sky130_hd_inv_1_6.Y sky130_hd_ro32_nand_0.sky130_hd_inv_1_7.Y 0.16f
C774 a_22065_35837# a_22058_35537# 0.975f
C775 sky130_hd_xor_block_3.XORB sky130_hd_ro33_nand_0.sky130_hd_inv_1_17.Y 3.26e-19
C776 sky130_hd_xor_block_0.sky130_hd_inv_1_3.A sky130_hd_xor_block_0.sky130_hd_xor2_1_0.A 0.00398f
C777 sky130_hd_ro41_nand_0.sky130_hd_inv_1_1.A VDPWR 0.471f
C778 sky130_hd_xor_block_2.sky130_hd_xor2_1_0.B sky130_hd_xor_block_3.sky130_hd_xor2_1_0.A 2.78e-19
C779 sky130_hd_ro53_nand_0.sky130_hd_inv_1_13.A sky130_hd_xor_block_0.XORB 7.87e-19
C780 sky130_hd_ro37_nand_0.sky130_hd_inv_1_2.A sky130_hd_ro33_nand_0.sky130_hd_inv_1_6.Y 6.23e-19
C781 sky130_hd_xor_block_3.XORA sky130_hd_ro33_nand_0.sky130_hd_inv_1_12.Y 4.99e-19
C782 sky130_hd_ro53_nand_0.sky130_hd_inv_1_47.Y sky130_hd_ro53_nand_0.sky130_hd_nand2_1_0.Y 2.03e-19
C783 a_27392_1891# a_27558_2979# 1.59e-19
C784 sky130_hd_ro32_nand_0.sky130_hd_inv_1_24.Y ua[0] 0.011f
C785 sky130_hd_xor_block_2.XORB sky130_hd_ro41_nand_0.sky130_hd_inv_1_31.Y 5.1e-19
C786 a_21429_33018# sky130_hd_xor_block_2.sky130_hd_xor2_1_0.B 8.18e-19
C787 a_28424_3247# a_28855_2213# 1.44e-21
C788 sky130_hd_ro33_nand_0.sky130_hd_inv_1_2.Y sky130_hd_ro33_nand_0.sky130_hd_inv_1_4.Y 5.04e-19
C789 sky130_hd_ro32_nand_0.sky130_hd_inv_1_2.Y a_27903_3755# 0.00171f
C790 a_27831_2257# a_27631_2762# 0.00875f
C791 sky130_hd_ro37_nand_0.sky130_hd_inv_1_17.Y sky130_hd_ro37_nand_0.sky130_hd_inv_1_19.Y 5.04e-19
C792 sky130_hd_ro33_nand_0.sky130_hd_inv_1_18.Y sky130_hd_ro33_nand_0.sky130_hd_inv_1_17.Y 0.16f
C793 a_27903_1579# sky130_hd_div_by_2_0.Qb 0.00346f
C794 sky130_hd_xor_block_2.XORB sky130_hd_ro41_nand_0.sky130_hd_inv_1_26.Y 5.1e-19
C795 sky130_hd_xor_block_3.XORA sky130_hd_ro33_nand_0.sky130_hd_inv_1_19.Y 4.99e-19
C796 VDPWR a_28324_1725# 0.179f
C797 sky130_hd_xor_block_0.XOROUT a_23743_35715# 7.21e-19
C798 sky130_hd_ro32_nand_0.sky130_hd_inv_1_21.Y ua[0] 0.011f
C799 sky130_hd_ro53_nand_0.sky130_hd_inv_1_31.Y sky130_hd_ro53_nand_0.sky130_hd_inv_1_29.Y 5.04e-19
C800 sky130_hd_ro32_nand_0.sky130_hd_inv_1_3.Y a_27631_3850# 0.00289f
C801 a_28571_3523# sky130_hd_div_by_2_3.Qb 5.04e-19
C802 a_28395_1624# a_28324_2813# 5.81e-20
C803 ua[0] a_27903_3755# 7.39e-19
C804 sky130_hd_ro47_nand_0.sky130_hd_inv_1_7.A sky130_hd_ro47_nand_0.sky130_hd_inv_1_9.A 5.04e-19
C805 VDPWR sky130_hd_ro32_nand_0.sky130_hd_inv_1_24.Y 0.419f
C806 a_28188_3741# sky130_hd_ro32_nand_0.sky130_hd_inv_1_1.Y 0.00113f
C807 sky130_hd_ro53_nand_0.sky130_hd_inv_1_22.Y sky130_hd_ro53_nand_0.sky130_hd_inv_1_21.A 5.04e-19
C808 ua[1] a_28195_1469# 0.00221f
C809 sky130_hd_ro47_nand_0.sky130_hd_inv_1_26.Y sky130_hd_xor_block_0.XORB 3.86e-19
C810 a_28855_2213# a_28195_1469# 6.08e-19
C811 sky130_hd_ro47_nand_0.sky130_hd_inv_1_43.Y sky130_hd_xor_block_0.XORB 0.00192f
C812 sky130_hd_ro47_nand_0.sky130_hd_inv_1_26.Y sky130_hd_xor_block_1.XORB 6.56e-19
C813 VDPWR a_24130_35837# 0.292f
C814 sky130_hd_ro47_nand_0.sky130_hd_inv_1_43.Y sky130_hd_xor_block_1.XORB 0.00602f
C815 sky130_hd_ro41_nand_0.sky130_hd_inv_1_28.Y sky130_hd_ro41_nand_0.sky130_hd_inv_1_26.Y 5.04e-19
C816 sky130_hd_ro37_nand_0.sky130_hd_inv_1_25.Y sky130_hd_xor_block_3.XORB 4.75e-19
C817 sky130_hd_xor_block_3.XORA sky130_hd_ro33_nand_0.sky130_hd_inv_1_1.Y 0.22f
C818 sky130_hd_ro37_nand_0.sky130_hd_inv_1_33.Y sky130_hd_ro37_nand_0.sky130_hd_inv_1_32.Y 0.16f
C819 sky130_hd_ro33_nand_0.sky130_hd_nand2_1_0.Y sky130_hd_ro33_nand_0.sky130_hd_inv_1_31.Y 0.172f
C820 VDPWR sky130_hd_ro53_nand_0.sky130_hd_inv_1_42.Y 0.474f
C821 sky130_hd_ro32_nand_0.sky130_hd_inv_1_21.Y VDPWR 0.419f
C822 VDPWR a_27631_2762# 0.523f
C823 a_27631_3850# a_27999_3091# 5.95e-19
C824 sky130_hd_ro53_nand_0.sky130_hd_inv_1_4.Y sky130_hd_ro53_nand_0.sky130_hd_inv_1_5.Y 0.159f
C825 sky130_hd_xor_block_0.XOROUT a_25118_30583# 0.00206f
C826 sky130_hd_ro41_nand_0.sky130_hd_inv_1_17.Y sky130_hd_xor_block_1.XORB 3.16e-19
C827 VDPWR a_27903_3755# 0.186f
C828 sky130_hd_ro47_nand_0.sky130_hd_inv_1_7.A sky130_hd_ro47_nand_0.sky130_hd_inv_1_18.Y 0.152f
C829 sky130_hd_div_by_2_3.Qb a_28340_3345# 6.89e-19
C830 sky130_hd_ro37_nand_0.sky130_hd_inv_1_26.Y sky130_hd_ro37_nand_0.sky130_hd_inv_1_25.Y 5.04e-19
C831 VDPWR sky130_hd_ro53_nand_0.sky130_hd_inv_1_17.A 0.494f
C832 sky130_hd_ro41_nand_0.sky130_hd_inv_1_20.Y sky130_hd_ro37_nand_0.sky130_hd_inv_1_19.Y 2.28e-19
C833 sky130_hd_xor_block_1.sky130_hd_inv_1_1.Y sky130_hd_xor_block_2.XOROUT 5.97e-19
C834 a_21261_33268# sky130_hd_xor_block_3.sky130_hd_xor2_1_0.A 9.78e-20
C835 sky130_hd_xor_block_2.XORB sky130_hd_ro37_nand_0.sky130_hd_inv_1_22.Y 3.07e-19
C836 sky130_hd_xor_block_3.XORA ui_in[4] 1.1e-20
C837 a_27392_1891# ua[1] 2.66e-19
C838 sky130_hd_xor_block_0.XORB sky130_hd_ro47_nand_0.sky130_hd_inv_1_3.Y 3.86e-19
C839 sky130_hd_ro53_nand_0.sky130_hd_inv_1_14.A sky130_hd_xor_block_0.XORB 7.87e-19
C840 VDPWR sky130_hd_ro37_nand_0.sky130_hd_inv_1_10.Y 0.436f
C841 sky130_hd_ro53_nand_0.sky130_hd_inv_1_32.Y sky130_hd_xor_block_0.XORB 7.87e-19
C842 clk ena 0.84f
C843 a_27392_1891# a_28855_2213# 1.73e-20
C844 sky130_hd_xor_block_1.sky130_hd_inv_1_3.A sky130_hd_xor_block_2.XOROUT 0.163f
C845 sky130_hd_xor_block_2.XORB sky130_hd_xor_block_2.XOROUT 6.29e-19
C846 sky130_hd_xor_block_1.XORB sky130_hd_ro47_nand_0.sky130_hd_inv_1_3.Y 0.00308f
C847 a_28188_1565# sky130_hd_div_by_2_3.Q 3.24e-20
C848 a_28742_1725# a_28188_1565# 0.0622f
C849 sky130_hd_ro53_nand_0.sky130_hd_inv_1_48.Y sky130_hd_ro53_nand_0.sky130_hd_inv_1_46.Y 5.04e-19
C850 a_24058_35563# a_23743_35715# 7.84e-20
C851 a_27903_1579# a_28324_1725# 0.0368f
C852 VDPWR sky130_hd_ro47_nand_0.sky130_hd_inv_1_36.Y 0.474f
C853 a_27392_2979# sky130_hd_div_by_2_4.Qb 0.00231f
C854 a_27392_2979# a_27536_3497# 0.00737f
C855 sky130_hd_ro32_nand_0.sky130_hd_inv_1_28.Y sky130_hd_ro32_nand_0.sky130_hd_nand2_1_0.Y 3.32e-19
C856 sky130_hd_ro47_nand_0.sky130_hd_inv_1_42.Y sky130_hd_xor_block_0.XORB 0.00109f
C857 sky130_hd_ro37_nand_0.sky130_hd_inv_1_12.Y sky130_hd_ro37_nand_0.sky130_hd_inv_1_10.Y 5.04e-19
C858 sky130_hd_ro41_nand_0.sky130_hd_inv_1_5.A sky130_hd_xor_block_2.XORB 8.62e-19
C859 sky130_hd_xor_block_1.XORB sky130_hd_ro47_nand_0.sky130_hd_inv_1_42.Y 0.0035f
C860 VDPWR a_23186_31740# 1.91e-19
C861 VDPWR sky130_hd_ro37_nand_0.sky130_hd_inv_1_15.Y 0.442f
C862 sky130_hd_ro53_nand_0.sky130_hd_inv_1_10.Y VDPWR 0.437f
C863 sky130_hd_xor_block_1.sky130_hd_inv_1_1.Y sky130_hd_xor_block_1.sky130_hd_xor2_1_0.B 5.97e-19
C864 sky130_hd_div_by_2_2.Q a_28146_2435# 6e-19
C865 sky130_hd_xor_block_0.XOROUT a_24123_35537# 0.125f
C866 a_27746_2979# a_27926_3345# 0.00123f
C867 sky130_hd_ro33_nand_0.sky130_hd_inv_1_2.Y sky130_hd_ro33_nand_0.sky130_hd_inv_1_3.Y 0.16f
C868 VDPWR sky130_hd_ro37_nand_0.sky130_hd_inv_1_32.Y 0.463f
C869 sky130_hd_ro53_nand_0.sky130_hd_inv_1_24.Y sky130_hd_xor_block_0.XORB 7.87e-19
C870 sky130_hd_xor_block_3.XOROUT sky130_hd_xor_block_2.sky130_hd_inv_1_1.Y 5.97e-19
C871 sky130_hd_ro32_nand_0.sky130_hd_inv_1_2.Y ua[0] 0.015f
C872 a_27558_1891# a_27999_3091# 8.47e-22
C873 a_28324_3901# a_27903_3755# 0.0368f
C874 VDPWR sky130_hd_ro37_nand_0.sky130_hd_inv_1_21.Y 0.442f
C875 a_27631_3850# a_27558_2979# 0.00702f
C876 a_24259_35563# a_24130_35837# 0.127f
C877 uio_in[7] uio_in[6] 0.031f
C878 a_27631_3850# a_28123_3889# 7.8e-20
C879 sky130_hd_ro47_nand_0.sky130_hd_inv_1_14.A sky130_hd_ro47_nand_0.sky130_hd_inv_1_15.A 0.16f
C880 sky130_hd_xor_block_1.sky130_hd_inv_1_3.A sky130_hd_xor_block_1.sky130_hd_xor2_1_0.B 0.16f
C881 a_28544_3889# a_28395_3800# 0.00553f
C882 sky130_hd_ro53_nand_0.sky130_hd_inv_1_7.Y sky130_hd_ro53_nand_0.sky130_hd_inv_1_5.Y 5.04e-19
C883 sky130_hd_xor_block_2.XORB sky130_hd_ro37_nand_0.sky130_hd_inv_1_35.Y 3.07e-19
C884 sky130_hd_xor_block_1.sky130_hd_xor2_1_0.A a_23186_31990# 0.0166f
C885 a_28146_3523# sky130_hd_div_by_2_4.Qb 3.52e-19
C886 sky130_hd_ro37_nand_0.sky130_hd_inv_1_11.Y sky130_hd_ro37_nand_0.sky130_hd_inv_1_10.Y 0.16f
C887 sky130_hd_xor_block_3.XORA sky130_hd_ro33_nand_0.sky130_hd_inv_1_9.Y 4.99e-19
C888 a_27903_1579# a_27631_2762# 8.53e-20
C889 sky130_hd_ro47_nand_0.sky130_hd_inv_1_37.Y sky130_hd_ro47_nand_0.sky130_hd_inv_1_35.A 2.69e-19
C890 a_28382_2979# sky130_hd_div_by_2_3.Q 1.28e-19
C891 sky130_hd_ro32_nand_0.sky130_hd_inv_1_7.Y sky130_hd_ro32_nand_0.sky130_hd_inv_1_8.Y 0.16f
C892 sky130_hd_xor_block_3.XORB sky130_hd_ro33_nand_0.sky130_hd_inv_1_24.Y 3.26e-19
C893 a_22065_35837# a_23743_35715# 1.12e-20
C894 sky130_hd_xor_block_0.sky130_hd_xor2_1_0.A sky130_hd_xor_block_1.XOROUT 0.00538f
C895 uo_out[0] a_22065_35837# 3.95e-20
C896 a_24123_35537# a_24506_35929# 0.0027f
C897 VDPWR sky130_hd_ro37_nand_0.sky130_hd_inv_1_33.Y 0.447f
C898 uio_in[5] uio_in[4] 0.031f
C899 a_28424_3247# a_28256_3345# 0.311f
C900 sky130_hd_ro32_nand_0.sky130_hd_inv_1_2.Y VDPWR 0.417f
C901 a_28256_3345# a_28395_3800# 0.00138f
C902 sky130_hd_ro37_nand_0.sky130_hd_inv_1_23.Y sky130_hd_ro37_nand_0.sky130_hd_inv_1_22.Y 0.16f
C903 ua[0] sky130_hd_ro32_nand_0.sky130_hd_inv_1_27.Y 0.0114f
C904 sky130_hd_ro47_nand_0.sky130_hd_inv_1_39.Y sky130_hd_xor_block_0.XORB 3.86e-19
C905 sky130_hd_ro53_nand_0.sky130_hd_inv_1_2.Y sky130_hd_ro53_nand_0.sky130_hd_inv_1_1.Y 0.16f
C906 a_28544_2801# a_28195_2557# 0.00135f
C907 sky130_hd_xor_block_2.XORB sky130_hd_ro37_nand_0.sky130_hd_inv_1_13.Y 3.07e-19
C908 sky130_hd_xor_block_3.XORA sky130_hd_xor_block_3.XORB 0.0765f
C909 sky130_hd_xor_block_1.XORB sky130_hd_ro47_nand_0.sky130_hd_inv_1_39.Y 6.56e-19
C910 VDPWR sky130_hd_xor_block_2.sky130_hd_xor2_1_0.A 0.696f
C911 sky130_hd_ro47_nand_0.sky130_hd_inv_1_34.Y sky130_hd_ro47_nand_0.sky130_hd_inv_1_35.Y 0.16f
C912 VDPWR ui_in[7] 0.777f
C913 sky130_hd_xor_block_2.XORB sky130_hd_ro37_nand_0.sky130_hd_inv_1_6.A 3.07e-19
C914 a_28424_2159# a_28424_3247# 0.00118f
C915 sky130_hd_ro41_nand_0.sky130_hd_inv_1_1.A sky130_hd_ro41_nand_0.sky130_hd_inv_1_3.A 5.04e-19
C916 sky130_hd_div_by_2_4.Q a_28188_3741# 0.00642f
C917 a_27831_2257# VDPWR 0.249f
C918 a_24950_30833# sky130_hd_xor_block_1.XOROUT 2e-19
C919 a_27558_1891# a_27957_1891# 0.00135f
C920 a_27558_2979# a_27558_1891# 3.34e-19
C921 VDPWR ua[0] 2.46f
C922 sky130_hd_ro53_nand_0.sky130_hd_inv_1_21.A sky130_hd_ro53_nand_0.sky130_hd_inv_1_20.A 0.16f
C923 sky130_hd_xor_block_0.XOROUT a_24479_35563# 7.59e-19
C924 sky130_hd_div_by_2_1.CLK a_28855_3301# 1.06e-20
C925 a_28424_3247# a_28195_2557# 0.00175f
C926 a_28195_2557# a_28395_3800# 8.17e-21
C927 sky130_hd_xor_block_3.XORA sky130_hd_ro33_nand_0.sky130_hd_inv_1_18.Y 4.99e-19
C928 sky130_hd_xor_block_3.sky130_hd_xor2_1_0.B sky130_hd_xor_block_3.sky130_hd_xor2_1_0.A 0.315f
C929 sky130_hd_ro47_nand_0.sky130_hd_nand2_1_0.Y sky130_hd_ro47_nand_0.sky130_hd_inv_1_40.Y 5.97e-20
C930 sky130_hd_xor_block_2.XORB sky130_hd_ro41_nand_0.sky130_hd_inv_1_30.Y 5.1e-19
C931 sky130_hd_inv_1_0.A a_22058_35537# 0.00876f
C932 a_28195_3645# a_28544_3889# 0.00135f
C933 VDPWR sky130_hd_ro32_nand_0.sky130_hd_inv_1_27.Y 0.419f
C934 sky130_hd_xor_block_2.XORB sky130_hd_ro41_nand_0.sky130_hd_inv_1_6.A 0.00146f
C935 sky130_hd_div_by_2_0.Qb a_28195_1469# 0.00157f
C936 a_22265_35537# a_22065_35837# 0.083f
C937 a_28742_2813# sky130_hd_div_by_2_2.Qb 0.147f
C938 sky130_hd_ro37_nand_0.sky130_hd_inv_1_4.A sky130_hd_ro37_nand_0.sky130_hd_inv_1_6.A 5.04e-19
C939 a_28424_2159# a_28195_1469# 0.00175f
C940 VDPWR sky130_hd_ro41_nand_0.sky130_hd_inv_1_39.Y 0.418f
C941 sky130_hd_ro33_nand_0.sky130_hd_inv_1_15.Y sky130_hd_ro33_nand_0.sky130_hd_inv_1_13.Y 5.04e-19
C942 ena sky130_hd_ro32_nand_0.sky130_hd_inv_1_1.Y 1.99e-19
C943 sky130_hd_ro32_nand_0.sky130_hd_inv_1_26.Y sky130_hd_ro32_nand_0.sky130_hd_inv_1_24.Y 5.04e-19
C944 sky130_hd_ro37_nand_0.sky130_hd_inv_1_17.Y sky130_hd_ro37_nand_0.sky130_hd_inv_1_18.Y 0.152f
C945 sky130_hd_ro33_nand_0.sky130_hd_nand2_1_0.Y ui_in[4] 4.86e-19
C946 sky130_hd_xor_block_2.XORB sky130_hd_ro41_nand_0.sky130_hd_inv_1_25.Y 5.1e-19
C947 sky130_hd_ro47_nand_0.sky130_hd_inv_1_10.A sky130_hd_xor_block_0.XORB 3.86e-19
C948 sky130_hd_xor_block_3.XOROUT a_19695_33932# 0.0712f
C949 sky130_hd_ro41_nand_0.sky130_hd_inv_1_37.Y sky130_hd_ro41_nand_0.sky130_hd_inv_1_38.Y 0.16f
C950 a_28195_2557# a_28195_1469# 3.34e-19
C951 a_27392_1891# a_27831_3345# 4.6e-21
C952 ua[0] sky130_hd_ro32_nand_0.sky130_hd_inv_1_14.Y 0.0108f
C953 sky130_hd_xor_block_1.XORB sky130_hd_ro47_nand_0.sky130_hd_inv_1_10.A 6.56e-19
C954 a_28195_3645# a_28256_3345# 8.74e-20
C955 sky130_hd_ro47_nand_0.sky130_hd_inv_1_26.Y sky130_hd_ro47_nand_0.sky130_hd_inv_1_24.Y 5.04e-19
C956 sky130_hd_ro41_nand_0.sky130_hd_inv_1_7.A sky130_hd_ro41_nand_0.sky130_hd_inv_1_9.A 5.04e-19
C957 a_28395_1624# sky130_hd_div_by_2_1.CLK 0.00111f
C958 VDPWR sky130_hd_ro41_nand_0.sky130_hd_inv_1_8.A 0.457f
C959 sky130_hd_div_by_2_1.Qb a_28146_1347# 6.79e-19
C960 sky130_hd_xor_block_3.XOROUT a_19695_33682# 0.00261f
C961 sky130_hd_ro32_nand_0.sky130_hd_inv_1_18.Y sky130_hd_ro32_nand_0.sky130_hd_inv_1_19.Y 0.16f
C962 a_28324_3901# ua[0] 8.71e-19
C963 sky130_hd_ro41_nand_0.sky130_hd_inv_1_10.A VDPWR 0.434f
C964 VDPWR sky130_hd_ro37_nand_0.sky130_hd_inv_1_12.Y 0.436f
C965 sky130_hd_ro53_nand_0.sky130_hd_inv_1_40.Y sky130_hd_xor_block_0.XORB 7.87e-19
C966 a_24123_35537# a_22065_35837# 2.33e-21
C967 a_22194_35563# VDPWR 0.181f
C968 a_21678_35715# a_22065_35837# 0.034f
C969 sky130_hd_ro41_nand_0.sky130_hd_inv_1_10.A sky130_hd_ro41_nand_0.sky130_hd_inv_1_8.A 5.04e-19
C970 sky130_hd_div_by_2_3.Q sky130_hd_div_by_2_4.Qb 0.0323f
C971 sky130_hd_div_by_2_2.Q a_27536_1321# 1.06e-20
C972 sky130_hd_ro47_nand_0.sky130_hd_inv_1_5.Y sky130_hd_ro47_nand_0.sky130_hd_inv_1_16.Y 0.16f
C973 sky130_hd_ro41_nand_0.sky130_hd_inv_1_24.Y sky130_hd_ro41_nand_0.sky130_hd_inv_1_23.Y 0.16f
C974 a_25118_30833# a_24868_30833# 0.0244f
C975 sky130_hd_ro33_nand_0.sky130_hd_inv_1_20.Y sky130_hd_ro33_nand_0.sky130_hd_inv_1_22.Y 5.04e-19
C976 a_28195_3645# a_28195_2557# 3.34e-19
C977 sky130_hd_div_by_2_0.Qb a_27392_1891# 0.12f
C978 sky130_hd_div_by_2_3.Qb sky130_hd_ro32_nand_0.sky130_hd_inv_1_1.Y 2.56e-22
C979 a_27903_1579# a_27831_2257# 0.00229f
C980 a_28256_2257# sky130_hd_div_by_2_2.Q 0.00143f
C981 sky130_hd_ro47_nand_0.sky130_hd_inv_1_14.A sky130_hd_ro47_nand_0.sky130_hd_inv_1_13.A 0.16f
C982 VDPWR sky130_hd_ro32_nand_0.sky130_hd_inv_1_14.Y 0.428f
C983 a_28424_2159# a_27392_1891# 0.0486f
C984 a_27746_2979# a_27392_2979# 0.0622f
C985 sky130_hd_ro41_nand_0.sky130_hd_inv_1_23.Y sky130_hd_ro41_nand_0.sky130_hd_inv_1_22.Y 0.16f
C986 a_27631_1674# a_28123_1713# 7.8e-20
C987 sky130_hd_div_by_2_4.Q sky130_hd_div_by_2_2.Qb 7.66e-19
C988 a_22612_35563# clk 0.00207f
C989 sky130_hd_ro41_nand_0.sky130_hd_inv_1_36.Y VDPWR 0.439f
C990 sky130_hd_xor_block_3.XOROUT sky130_hd_xor_block_3.sky130_hd_inv_1_3.A 1.62e-19
C991 sky130_hd_ro47_nand_0.sky130_hd_inv_1_41.Y sky130_hd_xor_block_0.XORB 3.86e-19
C992 ua[1] a_27558_1891# 1.57e-19
C993 a_28324_3901# VDPWR 0.183f
C994 a_27392_1891# a_28195_2557# 0.0113f
C995 sky130_hd_ro53_nand_0.sky130_hd_inv_1_29.Y sky130_hd_ro53_nand_0.sky130_hd_inv_1_30.Y 0.16f
C996 VDPWR sky130_hd_ro37_nand_0.sky130_hd_inv_1_11.Y 0.434f
C997 a_27558_1891# a_28855_2213# 2.25e-19
C998 sky130_hd_ro47_nand_0.sky130_hd_inv_1_41.Y sky130_hd_xor_block_1.XORB 0.00113f
C999 a_24330_35537# a_24130_35837# 0.083f
C1000 sky130_hd_ro32_nand_0.sky130_hd_inv_1_6.Y sky130_hd_ro32_nand_0.sky130_hd_inv_1_4.Y 5.04e-19
C1001 sky130_hd_ro47_nand_0.sky130_hd_inv_1_44.Y sky130_hd_xor_block_0.XORB 0.00192f
C1002 sky130_hd_ro53_nand_0.sky130_hd_inv_1_45.Y sky130_hd_ro53_nand_0.sky130_hd_inv_1_46.Y 0.16f
C1003 a_27999_2003# sky130_hd_div_by_2_2.Q 0.00156f
C1004 a_28742_2813# a_28395_2712# 0.0373f
C1005 sky130_hd_ro47_nand_0.sky130_hd_inv_1_44.Y sky130_hd_xor_block_1.XORB 0.00768f
C1006 sky130_hd_ro33_nand_0.sky130_hd_nand2_1_0.Y sky130_hd_xor_block_3.XORB 0.0015f
C1007 sky130_hd_ro37_nand_0.sky130_hd_inv_1_11.Y sky130_hd_ro37_nand_0.sky130_hd_inv_1_12.Y 0.16f
C1008 a_28324_1725# a_28195_1469# 0.127f
C1009 sky130_hd_ro47_nand_0.sky130_hd_inv_1_31.Y sky130_hd_ro47_nand_0.sky130_hd_inv_1_33.Y 5.04e-19
C1010 sky130_hd_ro53_nand_0.sky130_hd_inv_1_22.A sky130_hd_ro53_nand_0.sky130_hd_inv_1_11.Y 5.04e-19
C1011 sky130_hd_ro53_nand_0.sky130_hd_inv_1_51.Y ui_in[7] 0.00107f
C1012 sky130_hd_ro53_nand_0.sky130_hd_nand2_1_0.Y sky130_hd_ro53_nand_0.sky130_hd_inv_1_50.Y 0.0021f
C1013 sky130_hd_ro33_nand_0.sky130_hd_inv_1_2.Y sky130_hd_ro37_nand_0.sky130_hd_inv_1_6.A 2.28e-19
C1014 VDPWR sky130_hd_ro41_nand_0.sky130_hd_inv_1_18.Y 0.465f
C1015 a_28544_1713# a_28395_1624# 0.00553f
C1016 sky130_hd_ro53_nand_0.sky130_hd_inv_1_35.Y sky130_hd_ro53_nand_0.sky130_hd_inv_1_37.Y 5.04e-19
C1017 sky130_hd_ro47_nand_0.sky130_hd_inv_1_14.A sky130_hd_ro47_nand_0.sky130_hd_inv_1_12.A 5.04e-19
C1018 sky130_hd_xor_block_1.XORB sky130_hd_ro41_nand_0.sky130_hd_inv_1_31.Y 3.16e-19
C1019 ena sky130_hd_ro32_nand_0.sky130_hd_inv_1_12.Y 1.99e-19
C1020 a_24259_35563# VDPWR 0.179f
C1021 sky130_hd_ro37_nand_0.sky130_hd_inv_1_19.Y sky130_hd_ro37_nand_0.sky130_hd_inv_1_21.Y 5.04e-19
C1022 a_28188_2653# a_28855_3301# 0.0084f
C1023 a_27903_1579# VDPWR 0.185f
C1024 a_27957_1891# sky130_hd_div_by_2_1.CLK 9.74e-20
C1025 sky130_hd_ro53_nand_0.sky130_hd_inv_1_29.Y sky130_hd_ro53_nand_0.sky130_hd_inv_1_27.Y 5.04e-19
C1026 VDPWR sky130_hd_ro33_nand_0.sky130_hd_inv_1_11.Y 0.436f
C1027 sky130_hd_div_by_2_1.Qb a_28395_1624# 0.0214f
C1028 sky130_hd_ro41_nand_0.sky130_hd_inv_1_26.Y sky130_hd_xor_block_1.XORB 3.16e-19
C1029 sky130_hd_ro32_nand_0.sky130_hd_inv_1_11.Y sky130_hd_ro32_nand_0.sky130_hd_inv_1_10.Y 0.16f
C1030 sky130_hd_ro47_nand_0.sky130_hd_inv_1_11.A sky130_hd_xor_block_0.XORB 3.86e-19
C1031 a_28571_1347# a_28188_1565# 0.0027f
C1032 sky130_hd_xor_block_1.XORB sky130_hd_ro47_nand_0.sky130_hd_inv_1_11.A 6.56e-19
C1033 VDPWR sky130_hd_ro33_nand_0.sky130_hd_inv_1_23.Y 0.44f
C1034 a_28742_2813# sky130_hd_div_by_2_3.Qb 0.00101f
C1035 sky130_hd_ro41_nand_0.sky130_hd_inv_1_23.Y sky130_hd_ro41_nand_0.sky130_hd_inv_1_21.Y 5.04e-19
C1036 sky130_hd_ro32_nand_0.sky130_hd_inv_1_16.Y sky130_hd_ro32_nand_0.sky130_hd_inv_1_15.Y 0.16f
C1037 VDPWR sky130_hd_ro33_nand_0.sky130_hd_inv_1_29.Y 0.442f
C1038 VDPWR sky130_hd_ro47_nand_0.sky130_hd_inv_1_21.Y 0.447f
C1039 a_27631_1674# ua[1] 0.158f
C1040 VDPWR sky130_hd_ro53_nand_0.sky130_hd_inv_1_4.Y 0.501f
C1041 a_28123_1713# sky130_hd_div_by_2_1.CLK 6.39e-20
C1042 uo_out[0] a_22016_35929# 8.71e-20
C1043 sky130_hd_ro47_nand_0.sky130_hd_inv_1_32.Y sky130_hd_xor_block_0.XORB 3.86e-19
C1044 sky130_hd_div_by_2_2.Qb sky130_hd_div_by_2_2.Q 0.148f
C1045 a_23018_31990# sky130_hd_xor_block_2.XOROUT 2.02e-19
C1046 VDPWR sky130_hd_ro47_nand_0.sky130_hd_inv_1_16.A 0.443f
C1047 VDPWR sky130_hd_ro41_nand_0.sky130_hd_inv_1_29.Y 0.439f
C1048 sky130_hd_ro47_nand_0.sky130_hd_inv_1_32.Y sky130_hd_xor_block_1.XORB 6.56e-19
C1049 VDPWR sky130_hd_ro41_nand_0.sky130_hd_inv_1_32.Y 0.504f
C1050 a_27392_1891# a_28324_1725# 4.86e-19
C1051 a_27631_3850# a_27831_3345# 0.00875f
C1052 a_28188_2653# a_28395_1624# 4.6e-21
C1053 sky130_hd_xor_block_1.sky130_hd_inv_1_1.Y sky130_hd_xor_block_1.XOROUT 8.03e-19
C1054 sky130_hd_ro37_nand_0.sky130_hd_inv_1_25.Y sky130_hd_ro33_nand_0.sky130_hd_inv_1_25.Y 6.23e-19
C1055 VDPWR sky130_hd_ro53_nand_0.sky130_hd_inv_1_51.Y 0.422f
C1056 a_27392_2979# a_28855_3301# 1.73e-20
C1057 sky130_hd_ro47_nand_0.sky130_hd_inv_1_16.Y sky130_hd_ro47_nand_0.sky130_hd_inv_1_4.Y 5.04e-19
C1058 uo_out[0] sky130_hd_inv_1_0.A 0.0302f
C1059 a_28571_3523# sky130_hd_div_by_2_4.Qb 3.67e-19
C1060 a_24081_35929# sky130_hd_dfxtp_1_1.Q 1.91e-19
C1061 a_22936_31990# sky130_hd_xor_block_2.XOROUT 5.19e-19
C1062 sky130_hd_xor_block_2.XORB sky130_hd_ro41_nand_0.sky130_hd_inv_1_35.Y 9.81e-19
C1063 sky130_hd_div_by_2_4.Q a_27536_2409# 1.06e-20
C1064 sky130_hd_ro47_nand_0.sky130_hd_inv_1_22.Y sky130_hd_xor_block_0.XORB 3.86e-19
C1065 a_28256_3345# a_28324_2813# 0.00273f
C1066 sky130_hd_xor_block_2.XORB sky130_hd_ro41_nand_0.sky130_hd_inv_1_4.A 5.21e-19
C1067 sky130_hd_xor_block_1.sky130_hd_inv_1_3.A sky130_hd_xor_block_1.XOROUT 1.23e-19
C1068 sky130_hd_ro47_nand_0.sky130_hd_inv_1_22.Y sky130_hd_xor_block_1.XORB 6.56e-19
C1069 a_27903_2667# a_27999_3091# 0.00273f
C1070 sky130_hd_ro32_nand_0.sky130_hd_inv_1_26.Y ua[0] 0.011f
C1071 sky130_hd_ro37_nand_0.sky130_hd_inv_1_11.Y sky130_hd_ro33_nand_0.sky130_hd_inv_1_11.Y 2.28e-19
C1072 sky130_hd_ro47_nand_0.sky130_hd_inv_1_38.Y sky130_hd_ro47_nand_0.sky130_hd_inv_1_37.Y 0.16f
C1073 a_28195_3645# a_27903_3755# 0.197f
C1074 sky130_hd_div_by_2_0.Qb a_28324_2813# 0.00223f
C1075 sky130_hd_xor_block_2.XORB sky130_hd_ro41_nand_0.sky130_hd_inv_1_16.Y 5.1e-19
C1076 a_28188_2653# a_27999_3091# 4.86e-19
C1077 a_28424_2159# a_28324_2813# 5.95e-19
C1078 sky130_hd_ro32_nand_0.sky130_hd_inv_1_26.Y sky130_hd_ro32_nand_0.sky130_hd_inv_1_27.Y 0.16f
C1079 sky130_hd_ro32_nand_0.sky130_hd_inv_1_20.Y ena 1.99e-19
C1080 a_27392_1891# a_27631_2762# 8.54e-19
C1081 a_23018_31990# sky130_hd_xor_block_1.sky130_hd_xor2_1_0.B 0.014f
C1082 sky130_hd_xor_block_0.XOROUT sky130_hd_dfxtp_1_1.Q 0.00744f
C1083 sky130_hd_ro32_nand_0.sky130_hd_inv_1_3.Y a_27392_2979# 1.23e-20
C1084 a_28195_2557# a_28324_2813# 0.127f
C1085 a_21179_33268# sky130_hd_xor_block_3.XOROUT 5.52e-19
C1086 a_27631_2762# a_28123_2801# 7.8e-20
C1087 sky130_hd_xor_block_1.XORB sky130_hd_xor_block_2.XOROUT 0.0554f
C1088 sky130_hd_div_by_2_4.Q sky130_hd_div_by_2_3.Qb 0.145f
C1089 sky130_hd_ro53_nand_0.sky130_hd_inv_1_25.Y sky130_hd_ro53_nand_0.sky130_hd_inv_1_27.Y 5.04e-19
C1090 sky130_hd_div_by_2_1.Qb a_27957_1891# 8.76e-19
C1091 sky130_hd_ro53_nand_0.sky130_hd_inv_1_41.Y sky130_hd_ro53_nand_0.sky130_hd_inv_1_41.A 0.16f
C1092 a_22936_31990# sky130_hd_xor_block_1.sky130_hd_xor2_1_0.B 0.34f
C1093 a_28340_3345# sky130_hd_div_by_2_4.Qb 2.57e-19
C1094 sky130_hd_ro53_nand_0.sky130_hd_inv_1_7.Y VDPWR 0.443f
C1095 sky130_hd_xor_block_3.XOROUT sky130_hd_xor_block_2.XOROUT 2.08e-19
C1096 VDPWR sky130_hd_ro32_nand_0.sky130_hd_inv_1_26.Y 0.419f
C1097 sky130_hd_ro53_nand_0.sky130_hd_inv_1_16.A sky130_hd_ro53_nand_0.sky130_hd_inv_1_17.A 0.16f
C1098 sky130_hd_xor_block_2.XORB sky130_hd_xor_block_2.sky130_hd_inv_1_3.A 5.97e-19
C1099 a_27746_2979# sky130_hd_div_by_2_3.Q 2.69e-19
C1100 a_27558_1891# a_27831_3345# 1.22e-20
C1101 VDPWR sky130_hd_ro41_nand_0.sky130_hd_inv_1_3.A 0.476f
C1102 sky130_hd_ro53_nand_0.sky130_hd_inv_1_11.Y sky130_hd_ro53_nand_0.sky130_hd_inv_1_22.Y 0.16f
C1103 ua[1] sky130_hd_div_by_2_1.CLK 1.9e-19
C1104 sky130_hd_ro37_nand_0.sky130_hd_inv_1_19.Y VDPWR 0.458f
C1105 sky130_hd_ro53_nand_0.sky130_hd_inv_1_38.Y VDPWR 0.438f
C1106 sky130_hd_xor_block_3.sky130_hd_inv_1_3.A sky130_hd_ro33_nand_0.sky130_hd_inv_1_1.Y 3.41e-20
C1107 sky130_hd_ro41_nand_0.sky130_hd_inv_1_5.A sky130_hd_xor_block_1.XORB 3.16e-19
C1108 sky130_hd_inv_1_0.A a_22265_35537# 0.00199f
C1109 sky130_hd_ro32_nand_0.sky130_hd_inv_1_11.Y sky130_hd_ro32_nand_0.sky130_hd_inv_1_9.Y 5.04e-19
C1110 a_28855_2213# sky130_hd_div_by_2_1.CLK 0.22f
C1111 a_24677_35563# a_24130_35837# 0.102f
C1112 sky130_hd_ro32_nand_0.sky130_hd_inv_1_20.Y sky130_hd_ro32_nand_0.sky130_hd_inv_1_22.Y 5.04e-19
C1113 sky130_hd_ro47_nand_0.sky130_hd_inv_1_29.Y VDPWR 0.44f
C1114 sky130_hd_xor_block_3.XORA sky130_hd_ro33_nand_0.sky130_hd_inv_1_21.Y 4.99e-19
C1115 sky130_hd_ro53_nand_0.sky130_hd_inv_1_44.Y sky130_hd_xor_block_0.XORB 7.87e-19
C1116 a_28424_3247# ua[0] 1.66e-19
C1117 a_24506_35929# sky130_hd_dfxtp_1_1.Q 1.04e-19
C1118 ua[0] a_28395_3800# 9.1e-19
C1119 sky130_hd_div_by_2_1.Qb a_28123_1713# 9.6e-19
C1120 VDPWR sky130_hd_xor_block_0.sky130_hd_inv_1_1.Y 0.467f
C1121 a_28395_2712# sky130_hd_div_by_2_2.Q 0.0011f
C1122 a_27392_2979# a_27999_3091# 0.141f
C1123 a_27558_2979# a_27903_2667# 0.00597f
C1124 sky130_hd_div_by_2_2.Q a_27536_2409# 0.218f
C1125 VDPWR a_19527_33932# 0.00831f
C1126 ui_in[1] ui_in[0] 0.031f
C1127 a_28188_2653# a_27558_2979# 0.00101f
C1128 sky130_hd_xor_block_3.XORA sky130_hd_ro33_nand_0.sky130_hd_inv_1_13.Y 4.99e-19
C1129 sky130_hd_ro37_nand_0.sky130_hd_inv_1_17.Y sky130_hd_xor_block_2.XORB 3.07e-19
C1130 sky130_hd_div_by_2_0.Qb a_27558_1891# 0.294f
C1131 sky130_hd_ro47_nand_0.sky130_hd_inv_1_26.Y sky130_hd_ro47_nand_0.sky130_hd_inv_1_27.Y 0.157f
C1132 sky130_hd_xor_block_3.XORA sky130_hd_xor_block_3.sky130_hd_xor2_1_0.B 0.00632f
C1133 sky130_hd_ro33_nand_0.sky130_hd_inv_1_25.Y sky130_hd_ro33_nand_0.sky130_hd_inv_1_24.Y 0.16f
C1134 sky130_hd_div_by_2_2.Qb a_28146_2435# 6.77e-19
C1135 sky130_hd_ro37_nand_0.sky130_hd_inv_1_25.A VDPWR 0.437f
C1136 a_28424_2159# a_27558_1891# 0.0341f
C1137 sky130_hd_xor_block_3.XORB sky130_hd_ro33_nand_0.sky130_hd_inv_1_4.Y 3.26e-19
C1138 sky130_hd_ro53_nand_0.sky130_hd_inv_1_41.Y sky130_hd_ro53_nand_0.sky130_hd_inv_1_39.Y 5.04e-19
C1139 sky130_hd_ro33_nand_0.sky130_hd_inv_1_3.Y sky130_hd_ro33_nand_0.sky130_hd_inv_1_1.Y 5.04e-19
C1140 a_21678_35715# sky130_hd_inv_1_0.A 0.155f
C1141 sky130_hd_xor_block_2.sky130_hd_xor2_1_0.B sky130_hd_xor_block_2.sky130_hd_inv_1_1.Y 5.97e-19
C1142 sky130_hd_xor_block_0.XOROUT sky130_hd_xor_block_0.sky130_hd_xor2_1_0.B 0.0243f
C1143 sky130_hd_ro47_nand_0.sky130_hd_inv_1_43.Y ui_in[6] 3.2e-20
C1144 sky130_hd_ro33_nand_0.sky130_hd_inv_1_5.Y sky130_hd_ro33_nand_0.sky130_hd_inv_1_7.Y 5.04e-19
C1145 VDPWR a_28424_3247# 0.523f
C1146 a_28324_1725# a_28324_2813# 3.37e-19
C1147 VDPWR a_24330_35537# 0.245f
C1148 sky130_hd_ro41_nand_0.sky130_hd_inv_1_2.A sky130_hd_ro41_nand_0.sky130_hd_inv_1_12.Y 2.69e-19
C1149 ua[0] a_28195_1469# 2.92e-19
C1150 sky130_hd_xor_block_3.XORB sky130_hd_ro33_nand_0.sky130_hd_inv_1_28.Y 3.26e-19
C1151 VDPWR a_28395_3800# 0.248f
C1152 a_27558_1891# a_28195_2557# 6.13e-20
C1153 sky130_hd_xor_block_3.XORA sky130_hd_ro33_nand_0.sky130_hd_inv_1_25.Y 4.99e-19
C1154 sky130_hd_div_by_2_3.Qb sky130_hd_div_by_2_2.Q 0.0109f
C1155 sky130_hd_ro53_nand_0.sky130_hd_inv_1_24.Y sky130_hd_ro53_nand_0.sky130_hd_inv_1_26.Y 5.04e-19
C1156 a_24058_35563# sky130_hd_dfxtp_1_1.Q 3.21e-19
C1157 sky130_hd_ro53_nand_0.sky130_hd_inv_1_29.Y sky130_hd_ro53_nand_0.sky130_hd_inv_1_28.Y 0.16f
C1158 sky130_hd_ro47_nand_0.sky130_hd_inv_1_19.Y sky130_hd_xor_block_0.XORB 3.86e-19
C1159 sky130_hd_xor_block_1.XORB sky130_hd_ro47_nand_0.sky130_hd_inv_1_19.Y 6.56e-19
C1160 sky130_hd_ro32_nand_0.sky130_hd_inv_1_6.Y ua[0] 0.0111f
C1161 a_27558_2979# a_27392_2979# 0.975f
C1162 sky130_hd_ro37_nand_0.sky130_hd_inv_1_14.Y sky130_hd_ro37_nand_0.sky130_hd_inv_1_13.Y 0.16f
C1163 sky130_hd_ro47_nand_0.sky130_hd_inv_1_8.A sky130_hd_xor_block_0.XORB 3.86e-19
C1164 VDPWR sky130_hd_ro47_nand_0.sky130_hd_inv_1_40.Y 0.434f
C1165 sky130_hd_ro47_nand_0.sky130_hd_inv_1_34.Y sky130_hd_xor_block_0.XORB 3.86e-19
C1166 a_28195_3645# ua[0] 0.011f
C1167 sky130_hd_ro53_nand_0.sky130_hd_inv_1_2.Y sky130_hd_xor_block_0.XORB 0.00694f
C1168 sky130_hd_ro47_nand_0.sky130_hd_inv_1_34.Y sky130_hd_xor_block_1.XORB 6.56e-19
C1169 VDPWR a_28195_1469# 0.294f
C1170 sky130_hd_div_by_2_3.Q a_28855_3301# 0.219f
C1171 sky130_hd_ro47_nand_0.sky130_hd_inv_1_8.A sky130_hd_xor_block_1.XORB 6.56e-19
C1172 sky130_hd_div_by_2_1.Qb ua[1] 0.146f
C1173 a_27631_2762# a_28324_2813# 1.28e-19
C1174 a_27831_2257# a_27392_1891# 0.273f
C1175 sky130_hd_ro41_nand_0.sky130_hd_inv_1_6.A sky130_hd_xor_block_1.XORB 3.16e-19
C1176 sky130_hd_ro41_nand_0.sky130_hd_inv_1_20.Y sky130_hd_xor_block_2.XORB 5.1e-19
C1177 sky130_hd_xor_block_1.XORB sky130_hd_ro41_nand_0.sky130_hd_inv_1_30.Y 3.16e-19
C1178 sky130_hd_div_by_2_1.Qb a_28855_2213# 0.00231f
C1179 sky130_hd_div_by_2_0.Qb a_27631_1674# 0.00995f
C1180 sky130_hd_ro47_nand_0.sky130_hd_nand2_1_0.Y sky130_hd_ro47_nand_0.sky130_hd_inv_1_45.Y 0.172f
C1181 sky130_hd_xor_block_0.sky130_hd_inv_1_3.A sky130_hd_xor_block_0.XORB 5.97e-19
C1182 a_27631_3850# a_27631_2762# 0.00118f
C1183 a_28324_3901# a_28424_3247# 5.95e-19
C1184 a_22065_35837# sky130_hd_dfxtp_1_1.Q 0.25f
C1185 a_28324_3901# a_28395_3800# 0.24f
C1186 sky130_hd_ro53_nand_0.sky130_hd_inv_1_10.Y sky130_hd_ro53_nand_0.sky130_hd_inv_1_8.Y 5.04e-19
C1187 sky130_hd_div_by_2_3.Q a_28742_3901# 0.00311f
C1188 sky130_hd_ro47_nand_0.sky130_hd_inv_1_28.Y sky130_hd_xor_block_0.XORB 3.86e-19
C1189 a_27631_3850# a_27903_3755# 0.311f
C1190 ua[0] sky130_hd_ro32_nand_0.sky130_hd_inv_1_31.Y 0.0181f
C1191 sky130_hd_div_by_2_0.Qb a_27746_1891# 0.147f
C1192 VDPWR sky130_hd_ro32_nand_0.sky130_hd_inv_1_6.Y 0.417f
C1193 sky130_hd_xor_block_1.XORB sky130_hd_ro47_nand_0.sky130_hd_inv_1_28.Y 6.56e-19
C1194 sky130_hd_xor_block_1.XORB sky130_hd_ro41_nand_0.sky130_hd_inv_1_25.Y 3.16e-19
C1195 a_6379_29870# sky130_hd_xor_block_1.XORB 4.57e-20
C1196 sky130_hd_xor_block_3.XORB sky130_hd_xor_block_3.sky130_hd_inv_1_3.A 5.97e-19
C1197 sky130_hd_ro47_nand_0.sky130_hd_inv_1_42.Y ui_in[6] 1.1e-20
C1198 VDPWR a_28195_3645# 0.298f
C1199 sky130_hd_ro47_nand_0.sky130_hd_inv_1_22.Y sky130_hd_ro47_nand_0.sky130_hd_inv_1_20.Y 5.04e-19
C1200 ui_in[5] sky130_hd_ro37_nand_0.sky130_hd_inv_1_35.Y 1.75e-19
C1201 a_28188_2653# a_28855_2213# 0.00737f
C1202 sky130_hd_ro41_nand_0.sky130_hd_inv_1_12.Y sky130_hd_ro41_nand_0.sky130_hd_inv_1_14.Y 5.04e-19
C1203 VDPWR sky130_hd_ro33_nand_0.sky130_hd_inv_1_14.Y 0.439f
C1204 a_28256_2257# a_27999_2003# 0.0368f
C1205 sky130_hd_ro32_nand_0.sky130_hd_inv_1_13.Y sky130_hd_ro32_nand_0.sky130_hd_inv_1_12.Y 0.16f
C1206 sky130_hd_ro41_nand_0.sky130_hd_inv_1_27.Y sky130_hd_ro41_nand_0.sky130_hd_inv_1_26.Y 0.16f
C1207 a_24259_35563# a_24330_35537# 0.24f
C1208 sky130_hd_xor_block_3.XORA ui_in[3] 0.372f
C1209 a_28742_1725# a_28395_1624# 0.0373f
C1210 sky130_hd_ro53_nand_0.sky130_hd_inv_1_29.Y sky130_hd_xor_block_0.XORB 7.87e-19
C1211 sky130_hd_ro53_nand_0.sky130_hd_inv_1_34.Y sky130_hd_ro53_nand_0.sky130_hd_inv_1_33.Y 0.152f
C1212 a_27392_1891# VDPWR 0.632f
C1213 sky130_hd_xor_block_0.sky130_hd_inv_1_3.A sky130_hd_xor_block_0.sky130_hd_xor2_1_0.B 0.16f
C1214 sky130_hd_ro53_nand_0.sky130_hd_inv_1_48.Y sky130_hd_xor_block_0.XORB 0.00318f
C1215 sky130_hd_ro47_nand_0.sky130_hd_inv_1_22.Y sky130_hd_ro47_nand_0.sky130_hd_inv_1_24.Y 5.04e-19
C1216 a_27957_2979# a_27999_3091# 4.62e-19
C1217 VDPWR sky130_hd_ro53_nand_0.sky130_hd_inv_1_16.A 0.487f
C1218 a_22612_35563# a_22441_35929# 0.00123f
C1219 a_24130_35837# a_23743_35715# 0.034f
C1220 VDPWR a_28123_2801# 4.56e-19
C1221 uo_out[0] uio_in[5] 0.00154f
C1222 sky130_hd_ro41_nand_0.sky130_hd_inv_1_1.A sky130_hd_ro41_nand_0.sky130_hd_inv_1_13.Y 5.04e-19
C1223 VDPWR sky130_hd_ro32_nand_0.sky130_hd_inv_1_31.Y 0.421f
C1224 sky130_hd_ro37_nand_0.sky130_hd_inv_1_22.Y sky130_hd_ro37_nand_0.sky130_hd_inv_1_20.Y 5.04e-19
C1225 sky130_hd_div_by_2_3.Q a_27999_3091# 0.00123f
C1226 sky130_hd_xor_block_3.XORB sky130_hd_ro33_nand_0.sky130_hd_inv_1_3.Y 3.26e-19
C1227 a_27558_1891# a_27631_2762# 0.00702f
C1228 a_27926_3345# a_27831_3345# 0.00772f
C1229 sky130_hd_ro37_nand_0.sky130_hd_inv_1_25.Y sky130_hd_ro37_nand_0.sky130_hd_inv_1_24.Y 0.16f
C1230 sky130_hd_xor_block_2.sky130_hd_xor2_1_0.A a_21429_33268# 0.0166f
C1231 sky130_hd_xor_block_2.XORB a_7207_31915# 5.72e-20
C1232 sky130_hd_div_by_2_0.Qb sky130_hd_div_by_2_1.CLK 0.17f
C1233 a_28324_3901# a_28195_3645# 0.127f
C1234 VDPWR a_22058_35537# 0.685f
C1235 a_27903_1579# a_28195_1469# 0.197f
C1236 sky130_hd_ro33_nand_0.sky130_hd_inv_1_15.Y sky130_hd_ro33_nand_0.sky130_hd_inv_1_17.Y 5.04e-19
C1237 a_28188_3741# sky130_hd_div_by_2_2.Qb 2.3e-20
C1238 sky130_hd_ro32_nand_0.sky130_hd_inv_1_9.Y sky130_hd_ro32_nand_0.sky130_hd_inv_1_7.Y 5.04e-19
C1239 a_28424_2159# sky130_hd_div_by_2_1.CLK 0.16f
C1240 sky130_hd_ro47_nand_0.sky130_hd_inv_1_12.A sky130_hd_ro47_nand_0.sky130_hd_inv_1_10.A 5.04e-19
C1241 sky130_hd_ro32_nand_0.sky130_hd_inv_1_1.Y sky130_hd_div_by_2_4.Qb 0.0039f
C1242 a_28256_2257# sky130_hd_div_by_2_2.Qb 0.00361f
C1243 sky130_hd_ro37_nand_0.sky130_hd_inv_1_35.Y sky130_hd_ro37_nand_0.sky130_hd_nand2_1_0.Y 0.172f
C1244 sky130_hd_xor_block_3.XORB sky130_hd_ro33_nand_0.sky130_hd_inv_1_22.Y 3.26e-19
C1245 a_28195_2557# sky130_hd_div_by_2_1.CLK 0.007f
C1246 a_27631_1674# a_28324_1725# 1.28e-19
C1247 VDPWR a_24677_35563# 0.0754f
C1248 a_22194_35563# a_22058_35537# 0.141f
C1249 sky130_hd_ro37_nand_0.sky130_hd_inv_1_35.Y sky130_hd_ro37_nand_0.sky130_hd_inv_1_34.Y 0.16f
C1250 sky130_hd_xor_block_2.XORB sky130_hd_ro41_nand_0.sky130_hd_inv_1_1.A 5.1e-19
C1251 sky130_hd_ro33_nand_0.sky130_hd_inv_1_16.Y VDPWR 0.448f
C1252 VDPWR sky130_hd_ro53_nand_0.sky130_hd_inv_1_31.Y 0.447f
C1253 a_27631_3850# sky130_hd_ro32_nand_0.sky130_hd_inv_1_2.Y 0.00101f
C1254 sky130_hd_ro41_nand_0.sky130_hd_inv_1_6.A sky130_hd_ro37_nand_0.sky130_hd_inv_1_3.A 6.22e-19
C1255 sky130_hd_ro37_nand_0.sky130_hd_inv_1_18.Y VDPWR 0.503f
C1256 sky130_hd_xor_block_3.sky130_hd_inv_1_1.Y sky130_hd_xor_block_3.XOROUT 0.00116f
C1257 a_27558_2979# a_27957_2979# 0.00135f
C1258 VDPWR sky130_hd_xor_block_0.sky130_hd_xor2_1_0.A 0.69f
C1259 a_23018_31990# sky130_hd_xor_block_1.XOROUT 4.11e-20
C1260 a_27999_2003# sky130_hd_div_by_2_2.Qb 0.00251f
C1261 sky130_hd_ro41_nand_0.sky130_hd_inv_1_4.A sky130_hd_ro37_nand_0.sky130_hd_inv_1_1.A 2.28e-19
C1262 VDPWR sky130_hd_ro53_nand_0.sky130_hd_inv_1_8.Y 0.44f
C1263 sky130_hd_ro37_nand_0.sky130_hd_inv_1_35.Y ui_in[4] 9.39e-20
C1264 VDPWR sky130_hd_ro37_nand_0.sky130_hd_inv_1_5.A 0.457f
C1265 a_27558_2979# sky130_hd_div_by_2_3.Q 0.00276f
C1266 sky130_hd_ro41_nand_0.sky130_hd_inv_1_24.Y sky130_hd_ro41_nand_0.sky130_hd_inv_1_22.Y 5.04e-19
C1267 VDPWR a_21429_33268# 0.292f
C1268 sky130_hd_ro41_nand_0.sky130_hd_inv_1_15.Y sky130_hd_ro41_nand_0.sky130_hd_inv_1_14.Y 0.16f
C1269 a_27631_1674# a_27631_2762# 0.00118f
C1270 a_22936_31990# sky130_hd_xor_block_1.XOROUT 0.182f
C1271 sky130_hd_ro53_nand_0.sky130_hd_inv_1_25.Y sky130_hd_xor_block_0.XORB 7.87e-19
C1272 a_27903_1579# a_27392_1891# 2.74e-19
C1273 sky130_hd_ro41_nand_0.sky130_hd_inv_1_8.A sky130_hd_ro37_nand_0.sky130_hd_inv_1_5.A 6.22e-19
C1274 a_28571_3523# a_28742_3901# 0.00123f
C1275 a_27631_3850# ua[0] 5.66e-19
C1276 sky130_hd_ro47_nand_0.sky130_hd_inv_1_11.A sky130_hd_ro47_nand_0.sky130_hd_inv_1_13.A 5.04e-19
C1277 a_22065_35837# a_22414_35563# 0.00135f
C1278 sky130_hd_ro47_nand_0.sky130_hd_inv_1_20.Y sky130_hd_ro47_nand_0.sky130_hd_inv_1_19.Y 0.16f
C1279 clk a_24081_35929# 0.00139f
C1280 ua[0] sky130_hd_ro32_nand_0.sky130_hd_inv_1_8.Y 0.011f
C1281 sky130_hd_ro32_nand_0.sky130_hd_inv_1_29.Y ua[0] 0.0126f
C1282 VDPWR a_24950_30833# 0.00848f
C1283 sky130_hd_ro53_nand_0.sky130_hd_inv_1_42.Y sky130_hd_ro53_nand_0.sky130_hd_inv_1_41.A 0.157f
C1284 sky130_hd_div_by_2_0.Qb a_28544_1713# 9.52e-19
C1285 sky130_hd_ro53_nand_0.sky130_hd_inv_1_48.Y sky130_hd_ro53_nand_0.sky130_hd_inv_1_49.Y 0.16f
C1286 a_27631_2762# a_27746_1891# 4.18e-19
C1287 VDPWR sky130_hd_ro47_nand_0.sky130_hd_inv_1_16.Y 0.448f
C1288 VDPWR sky130_hd_ro47_nand_0.sky130_hd_inv_1_25.Y 0.436f
C1289 sky130_hd_xor_block_3.XORB sky130_hd_ro37_nand_0.sky130_hd_inv_1_22.Y 4.75e-19
C1290 a_24130_35837# a_24123_35537# 0.975f
C1291 a_27831_3345# a_27903_2667# 0.00229f
C1292 sky130_hd_xor_block_3.XORA sky130_hd_ro33_nand_0.sky130_hd_inv_1_6.Y 0.00103f
C1293 sky130_hd_ro32_nand_0.sky130_hd_inv_1_29.Y sky130_hd_ro32_nand_0.sky130_hd_inv_1_27.Y 5.04e-19
C1294 sky130_hd_ro37_nand_0.sky130_hd_inv_1_31.Y sky130_hd_ro37_nand_0.sky130_hd_inv_1_32.Y 0.16f
C1295 sky130_hd_xor_block_1.XORB sky130_hd_ro41_nand_0.sky130_hd_inv_1_35.Y 3.16e-19
C1296 VDPWR sky130_hd_ro33_nand_0.sky130_hd_inv_1_27.Y 0.438f
C1297 sky130_hd_div_by_2_0.Qb sky130_hd_div_by_2_1.Qb 0.295f
C1298 a_6379_29870# sky130_hd_ro41_nand_0.sky130_hd_nand2_1_0.Y 0.00964f
C1299 sky130_hd_div_by_2_1.CLK a_28324_1725# 9.5e-19
C1300 sky130_hd_xor_block_1.XORB sky130_hd_ro41_nand_0.sky130_hd_inv_1_4.A 3.16e-19
C1301 sky130_hd_xor_block_0.XORB sky130_hd_xor_block_1.XOROUT 0.0557f
C1302 VDPWR a_28324_2813# 0.184f
C1303 a_28188_3741# a_28395_2712# 4.6e-21
C1304 a_27536_1321# a_27536_2409# 7.51e-19
C1305 sky130_hd_ro33_nand_0.sky130_hd_inv_1_24.Y sky130_hd_ro37_nand_0.sky130_hd_inv_1_24.Y 6.23e-19
C1306 sky130_hd_inv_1_0.A sky130_hd_inv_4_0.A 0.176f
C1307 a_28256_2257# a_28395_2712# 0.00138f
C1308 sky130_hd_xor_block_1.XORB sky130_hd_xor_block_1.XOROUT 5.13e-19
C1309 a_28424_2159# sky130_hd_div_by_2_1.Qb 0.00917f
C1310 sky130_hd_ro33_nand_0.sky130_hd_nand2_1_0.Y ui_in[3] 0.0771f
C1311 sky130_hd_ro32_nand_0.sky130_hd_inv_1_17.Y ena 1.99e-19
C1312 a_27631_3850# VDPWR 0.522f
C1313 sky130_hd_xor_block_0.XOROUT clk 0.175f
C1314 a_24259_35563# a_24677_35563# 3.39e-19
C1315 VDPWR sky130_hd_ro32_nand_0.sky130_hd_inv_1_29.Y 0.419f
C1316 VDPWR sky130_hd_ro53_nand_0.sky130_hd_inv_1_46.Y 0.503f
C1317 sky130_hd_ro47_nand_0.sky130_hd_inv_1_12.A sky130_hd_ro47_nand_0.sky130_hd_inv_1_11.A 0.16f
C1318 sky130_hd_ro41_nand_0.sky130_hd_inv_1_16.Y sky130_hd_xor_block_1.XORB 3.16e-19
C1319 VDPWR sky130_hd_ro32_nand_0.sky130_hd_inv_1_8.Y 0.417f
C1320 uo_out[0] ui_in[7] 0.27f
C1321 sky130_hd_div_by_2_1.Qb a_28195_2557# 3.28e-21
C1322 a_27831_2257# a_27558_1891# 0.083f
C1323 sky130_hd_ro47_nand_0.sky130_hd_inv_1_35.Y sky130_hd_ro47_nand_0.sky130_hd_inv_1_36.Y 5.04e-19
C1324 sky130_hd_div_by_2_0.Qb a_27903_2667# 0.00343f
C1325 a_28188_2653# a_28256_3345# 2.74e-19
C1326 sky130_hd_ro37_nand_0.sky130_hd_inv_1_33.Y sky130_hd_ro37_nand_0.sky130_hd_inv_1_31.Y 5.04e-19
C1327 sky130_hd_ro47_nand_0.sky130_hd_inv_1_30.Y sky130_hd_xor_block_0.XORB 3.86e-19
C1328 a_28424_3247# a_28395_3800# 0.00875f
C1329 sky130_hd_div_by_2_0.Qb a_28188_2653# 0.00361f
C1330 sky130_hd_ro41_nand_0.sky130_hd_inv_1_20.Y sky130_hd_ro41_nand_0.sky130_hd_inv_1_19.Y 0.16f
C1331 sky130_hd_ro37_nand_0.sky130_hd_inv_1_35.Y sky130_hd_xor_block_3.XORB 0.0103f
C1332 sky130_hd_xor_block_2.XORB sky130_hd_ro37_nand_0.sky130_hd_inv_1_10.Y 3.07e-19
C1333 sky130_hd_xor_block_1.XORB sky130_hd_ro47_nand_0.sky130_hd_inv_1_30.Y 6.56e-19
C1334 sky130_hd_ro47_nand_0.sky130_hd_inv_1_44.Y ui_in[6] 5.12e-20
C1335 a_27926_2257# sky130_hd_div_by_2_2.Q 3.6e-19
C1336 a_28188_2653# a_28424_2159# 8.54e-19
C1337 a_28188_3741# sky130_hd_div_by_2_3.Qb 0.00402f
C1338 a_22016_35929# sky130_hd_dfxtp_1_1.Q 3.08e-22
C1339 a_28195_2557# a_27903_2667# 0.197f
C1340 clk a_24506_35929# 0.00137f
C1341 sky130_hd_ro41_nand_0.sky130_hd_inv_1_17.Y sky130_hd_ro37_nand_0.sky130_hd_inv_1_16.Y 6.22e-19
C1342 sky130_hd_xor_block_0.sky130_hd_xor2_1_0.B sky130_hd_xor_block_1.XOROUT 0.00797f
C1343 sky130_hd_ro41_nand_0.sky130_hd_inv_1_21.Y sky130_hd_ro41_nand_0.sky130_hd_inv_1_22.Y 0.152f
C1344 a_27831_3345# a_27392_2979# 0.273f
C1345 a_28324_3901# a_28324_2813# 3.37e-19
C1346 sky130_hd_ro53_nand_0.sky130_hd_inv_1_41.Y sky130_hd_xor_block_0.XORB 7.87e-19
C1347 sky130_hd_ro47_nand_0.sky130_hd_inv_1_31.Y sky130_hd_ro47_nand_0.sky130_hd_inv_1_32.Y 0.16f
C1348 a_28256_2257# sky130_hd_div_by_2_3.Qb 1.05e-20
C1349 sky130_hd_xor_block_3.XOROUT sky130_hd_xor_block_2.sky130_hd_inv_1_3.A 0.163f
C1350 a_28188_2653# a_28195_2557# 0.975f
C1351 sky130_hd_inv_1_0.A sky130_hd_dfxtp_1_1.Q 0.00621f
C1352 a_24479_35563# a_24130_35837# 0.00135f
C1353 a_27999_3091# a_28340_3345# 9.73e-19
C1354 a_28855_2213# sky130_hd_div_by_2_3.Q 2.93e-21
C1355 sky130_hd_xor_block_2.XORB sky130_hd_ro37_nand_0.sky130_hd_inv_1_15.Y 3.07e-19
C1356 a_28742_1725# ua[1] 2.11e-19
C1357 a_21179_33268# sky130_hd_xor_block_2.sky130_hd_xor2_1_0.B 0.34f
C1358 sky130_hd_div_by_2_4.Q a_27536_3497# 0.22f
C1359 a_27631_3850# a_28324_3901# 1.28e-19
C1360 sky130_hd_xor_block_3.XORA sky130_hd_xor_block_3.sky130_hd_xor2_1_0.A 0.00571f
C1361 sky130_hd_ro47_nand_0.sky130_hd_inv_1_5.Y sky130_hd_xor_block_0.XORB 3.86e-19
C1362 sky130_hd_xor_block_3.XORB sky130_hd_ro33_nand_0.sky130_hd_inv_1_26.Y 3.26e-19
C1363 sky130_hd_div_by_2_4.Q sky130_hd_div_by_2_4.Qb 0.122f
C1364 sky130_hd_xor_block_2.XORB sky130_hd_ro37_nand_0.sky130_hd_inv_1_32.Y 3.07e-19
C1365 sky130_hd_ro41_nand_0.sky130_hd_inv_1_15.Y sky130_hd_ro41_nand_0.sky130_hd_inv_1_17.Y 5.04e-19
C1366 sky130_hd_ro53_nand_0.sky130_hd_inv_1_45.Y sky130_hd_xor_block_0.XORB 7.87e-19
C1367 sky130_hd_xor_block_2.XORB sky130_hd_ro37_nand_0.sky130_hd_inv_1_21.Y 3.07e-19
C1368 sky130_hd_ro47_nand_0.sky130_hd_inv_1_5.Y sky130_hd_xor_block_1.XORB 0.00134f
C1369 VDPWR sky130_hd_ro33_nand_0.sky130_hd_inv_1_8.Y 0.44f
C1370 a_28544_1713# a_28324_1725# 4.62e-19
C1371 VDPWR a_27558_1891# 0.299f
C1372 sky130_hd_xor_block_3.XORB sky130_hd_ro37_nand_0.sky130_hd_inv_1_13.Y 4.75e-19
C1373 a_28256_3345# a_27392_2979# 0.0322f
C1374 uo_out[0] VDPWR 1.1f
C1375 sky130_hd_xor_block_1.sky130_hd_xor2_1_0.A sky130_hd_xor_block_2.XOROUT 0.00535f
C1376 VDPWR a_23743_35715# 0.398f
C1377 a_27999_2003# sky130_hd_div_by_2_3.Qb 5.36e-22
C1378 sky130_hd_xor_block_3.XORB sky130_hd_ro37_nand_0.sky130_hd_inv_1_6.A 0.155f
C1379 sky130_hd_xor_block_2.sky130_hd_xor2_1_0.B sky130_hd_xor_block_2.XOROUT 0.0273f
C1380 a_27831_2257# a_27631_1674# 0.00305f
C1381 sky130_hd_ro41_nand_0.sky130_hd_inv_1_27.Y sky130_hd_ro41_nand_0.sky130_hd_inv_1_25.Y 5.04e-19
C1382 a_24058_35563# clk 4.2e-19
C1383 sky130_hd_div_by_2_1.Qb a_28324_1725# 0.0261f
C1384 sky130_hd_div_by_2_2.Qb a_28395_2712# 0.0215f
C1385 sky130_hd_xor_block_3.XORA sky130_hd_ro33_nand_0.sky130_hd_inv_1_15.Y 4.99e-19
C1386 sky130_hd_xor_block_3.sky130_hd_xor2_1_0.B a_19695_33932# 0.057f
C1387 sky130_hd_ro47_nand_0.sky130_hd_inv_1_2.Y sky130_hd_ro47_nand_0.sky130_hd_inv_1_1.Y 0.16f
C1388 ui_in[3] ui_in[2] 0.0351f
C1389 sky130_hd_div_by_2_2.Qb a_27536_2409# 0.11f
C1390 a_28424_3247# a_28195_3645# 0.00702f
C1391 a_28195_3645# a_28395_3800# 0.083f
C1392 VDPWR sky130_hd_ro37_nand_0.sky130_hd_inv_1_31.Y 0.504f
C1393 ua[0] sky130_hd_ro32_nand_0.sky130_hd_inv_1_15.Y 0.011f
C1394 a_28571_1347# a_28395_1624# 0.00772f
C1395 sky130_hd_xor_block_2.XORB sky130_hd_ro37_nand_0.sky130_hd_inv_1_33.Y 3.07e-19
C1396 a_28195_2557# a_27392_2979# 0.00101f
C1397 a_27831_2257# a_27746_1891# 0.0373f
C1398 sky130_hd_ro47_nand_0.sky130_hd_inv_1_16.Y sky130_hd_ro47_nand_0.sky130_hd_inv_1_16.A 0.16f
C1399 sky130_hd_ro53_nand_0.sky130_hd_inv_1_10.Y sky130_hd_ro53_nand_0.sky130_hd_inv_1_9.Y 0.16f
C1400 sky130_hd_xor_block_3.sky130_hd_xor2_1_0.B a_19695_33682# 8.18e-19
C1401 sky130_hd_ro32_nand_0.sky130_hd_inv_1_28.Y ua[0] 0.012f
C1402 sky130_hd_ro33_nand_0.sky130_hd_inv_1_27.Y sky130_hd_ro33_nand_0.sky130_hd_inv_1_29.Y 5.04e-19
C1403 sky130_hd_xor_block_2.XORB sky130_hd_xor_block_2.sky130_hd_xor2_1_0.A 0.00992f
C1404 VDPWR a_25118_30583# 1.91e-19
C1405 sky130_hd_xor_block_1.sky130_hd_xor2_1_0.A sky130_hd_xor_block_1.sky130_hd_xor2_1_0.B 0.315f
C1406 a_27558_2979# a_28340_3345# 6.32e-19
C1407 a_28188_2653# a_28324_1725# 5.37e-21
C1408 sky130_hd_ro32_nand_0.sky130_hd_inv_1_28.Y sky130_hd_ro32_nand_0.sky130_hd_inv_1_27.Y 0.16f
C1409 VDPWR sky130_hd_ro41_nand_0.sky130_hd_inv_1_13.Y 0.436f
C1410 sky130_hd_div_by_2_1.Qb a_27631_2762# 1.81e-21
C1411 VDPWR a_22265_35537# 0.249f
C1412 sky130_hd_ro33_nand_0.sky130_hd_inv_1_30.Y sky130_hd_ro33_nand_0.sky130_hd_inv_1_31.Y 0.16f
C1413 a_27392_2979# sky130_hd_ro32_nand_0.sky130_hd_inv_1_4.Y 1.19e-19
C1414 sky130_hd_ro37_nand_0.sky130_hd_inv_1_19.Y sky130_hd_ro37_nand_0.sky130_hd_inv_1_18.Y 0.16f
C1415 sky130_hd_div_by_2_3.Qb sky130_hd_div_by_2_2.Qb 0.282f
C1416 VDPWR sky130_hd_ro47_nand_0.sky130_hd_inv_1_45.Y 0.42f
C1417 ui_in[4] a_8679_33959# 3.03e-20
C1418 sky130_hd_ro41_nand_0.sky130_hd_nand2_1_0.Y sky130_hd_ro41_nand_0.sky130_hd_inv_1_35.Y 2.03e-19
C1419 VDPWR a_27631_1674# 0.511f
C1420 clk a_22065_35837# 0.0251f
C1421 sky130_hd_xor_block_3.sky130_hd_xor2_1_0.B sky130_hd_xor_block_3.sky130_hd_inv_1_3.A 0.16f
C1422 VDPWR sky130_hd_ro32_nand_0.sky130_hd_inv_1_15.Y 0.419f
C1423 sky130_hd_ro53_nand_0.sky130_hd_inv_1_7.Y sky130_hd_ro53_nand_0.sky130_hd_inv_1_8.Y 0.16f
C1424 sky130_hd_ro41_nand_0.sky130_hd_inv_1_20.Y sky130_hd_xor_block_1.XORB 3.16e-19
C1425 sky130_hd_xor_block_3.XORA sky130_hd_ro33_nand_0.sky130_hd_inv_1_17.Y 4.99e-19
C1426 VDPWR sky130_hd_ro53_nand_0.sky130_hd_inv_1_1.Y 0.434f
C1427 sky130_hd_ro53_nand_0.sky130_hd_inv_1_34.Y sky130_hd_ro53_nand_0.sky130_hd_inv_1_36.Y 5.04e-19
C1428 sky130_hd_ro41_nand_0.sky130_hd_inv_1_13.Y sky130_hd_ro37_nand_0.sky130_hd_inv_1_12.Y 6.22e-19
C1429 a_21179_33268# a_21261_33268# 0.00294f
C1430 sky130_hd_ro47_nand_0.sky130_hd_inv_1_38.Y sky130_hd_ro47_nand_0.sky130_hd_inv_1_39.Y 0.16f
C1431 sky130_hd_ro37_nand_0.sky130_hd_inv_1_23.Y sky130_hd_ro37_nand_0.sky130_hd_inv_1_21.Y 5.04e-19
C1432 sky130_hd_ro41_nand_0.sky130_hd_inv_1_34.Y sky130_hd_ro41_nand_0.sky130_hd_inv_1_35.Y 0.16f
C1433 VDPWR sky130_hd_ro32_nand_0.sky130_hd_inv_1_28.Y 0.419f
C1434 VDPWR sky130_hd_ro47_nand_0.sky130_hd_inv_1_35.Y 0.448f
C1435 a_22194_35563# a_22265_35537# 0.24f
C1436 sky130_hd_xor_block_1.sky130_hd_inv_1_1.Y VDPWR 0.469f
C1437 sky130_hd_xor_block_0.sky130_hd_inv_1_1.Y sky130_hd_xor_block_0.sky130_hd_xor2_1_0.A 0.149f
C1438 a_27903_2667# a_27631_2762# 0.311f
C1439 VDPWR sky130_hd_ro53_nand_0.sky130_hd_inv_1_41.A 0.438f
C1440 VDPWR a_27746_1891# 0.0754f
C1441 a_24259_35563# a_23743_35715# 1.28e-19
C1442 a_27903_1579# a_27558_1891# 0.00597f
C1443 a_27831_2257# sky130_hd_div_by_2_1.CLK 0.00121f
C1444 a_28188_2653# a_27631_2762# 0.0486f
C1445 a_19286_4740# ena 1.69e-19
C1446 a_21261_33268# sky130_hd_xor_block_2.XOROUT 4.11e-20
C1447 a_27392_1891# a_28195_1469# 0.00101f
C1448 sky130_hd_xor_block_2.XORB sky130_hd_ro41_nand_0.sky130_hd_inv_1_39.Y 0.0137f
C1449 sky130_hd_ro53_nand_0.sky130_hd_inv_1_34.Y sky130_hd_xor_block_0.XORB 7.87e-19
C1450 a_27903_2667# a_27903_3755# 6.58e-19
C1451 sky130_hd_inv_1_0.A a_21993_35563# 1.86e-19
C1452 sky130_hd_ro37_nand_0.sky130_hd_inv_1_34.Y sky130_hd_ro41_nand_0.sky130_hd_inv_1_35.Y 6.22e-19
C1453 sky130_hd_ro41_nand_0.sky130_hd_inv_1_33.Y sky130_hd_ro41_nand_0.sky130_hd_inv_1_31.Y 5.04e-19
C1454 sky130_hd_ro37_nand_0.sky130_hd_inv_1_2.A sky130_hd_ro41_nand_0.sky130_hd_inv_1_5.A 2.28e-19
C1455 VDPWR a_19445_33932# 0.253f
C1456 sky130_hd_xor_block_2.XORB VDPWR 3.71f
C1457 a_24330_35537# a_24677_35563# 0.0373f
C1458 ua[0] sky130_hd_div_by_2_1.CLK 0.0361f
C1459 VDPWR sky130_hd_xor_block_1.sky130_hd_inv_1_3.A 0.465f
C1460 a_28256_2257# a_28382_1891# 0.00617f
C1461 VDPWR a_24123_35537# 0.677f
C1462 a_28188_2653# a_27903_3755# 1.62e-20
C1463 sky130_hd_xor_block_0.XORB sky130_hd_ro47_nand_0.sky130_hd_inv_1_4.Y 3.86e-19
C1464 ui_in[3] sky130_hd_ro33_nand_0.sky130_hd_inv_1_28.Y 1.1e-20
C1465 sky130_hd_ro47_nand_0.sky130_hd_nand2_1_0.Y sky130_hd_xor_block_0.XORB 0.00216f
C1466 a_21678_35715# VDPWR 0.402f
C1467 sky130_hd_xor_block_2.XORB sky130_hd_ro41_nand_0.sky130_hd_inv_1_8.A 0.00358f
C1468 a_27831_3345# a_27957_2979# 0.00553f
C1469 sky130_hd_ro53_nand_0.sky130_hd_inv_1_15.A sky130_hd_ro53_nand_0.sky130_hd_inv_1_17.A 5.04e-19
C1470 sky130_hd_ro47_nand_0.sky130_hd_inv_1_10.A sky130_hd_ro47_nand_0.sky130_hd_inv_1_9.A 0.157f
C1471 sky130_hd_ro32_nand_0.sky130_hd_inv_1_15.Y sky130_hd_ro32_nand_0.sky130_hd_inv_1_14.Y 0.16f
C1472 sky130_hd_ro33_nand_0.sky130_hd_inv_1_21.Y sky130_hd_ro33_nand_0.sky130_hd_inv_1_22.Y 0.157f
C1473 sky130_hd_xor_block_1.XORB sky130_hd_ro47_nand_0.sky130_hd_inv_1_4.Y 0.00192f
C1474 sky130_hd_ro47_nand_0.sky130_hd_nand2_1_0.Y sky130_hd_xor_block_1.XORB 0.234f
C1475 sky130_hd_ro41_nand_0.sky130_hd_inv_1_10.A sky130_hd_xor_block_2.XORB 0.173f
C1476 a_27831_3345# sky130_hd_div_by_2_3.Q 0.00121f
C1477 sky130_hd_xor_block_2.XORB sky130_hd_ro37_nand_0.sky130_hd_inv_1_12.Y 3.07e-19
C1478 VDPWR sky130_hd_ro33_nand_0.sky130_hd_inv_1_7.Y 0.443f
C1479 sky130_hd_inv_1_0.A a_22414_35563# 1.13e-19
C1480 VDPWR sky130_hd_ro53_nand_0.sky130_hd_inv_1_33.Y 0.55f
C1481 sky130_hd_ro33_nand_0.sky130_hd_inv_1_5.Y sky130_hd_ro37_nand_0.sky130_hd_inv_1_3.A 2.28e-19
C1482 sky130_hd_ro53_nand_0.sky130_hd_inv_1_5.Y sky130_hd_xor_block_0.XORB 0.00169f
C1483 a_22194_35563# a_21678_35715# 1.28e-19
C1484 VDPWR sky130_hd_ro37_nand_0.sky130_hd_inv_1_27.Y 0.442f
C1485 VDPWR sky130_hd_ro37_nand_0.sky130_hd_inv_1_4.A 0.501f
C1486 VDPWR sky130_hd_ro53_nand_0.sky130_hd_inv_1_30.Y 0.442f
C1487 a_28382_1891# a_27999_2003# 4.67e-20
C1488 sky130_hd_ro32_nand_0.sky130_hd_inv_1_23.Y ena 1.99e-19
C1489 sky130_hd_ro41_nand_0.sky130_hd_inv_1_28.Y VDPWR 0.437f
C1490 sky130_hd_xor_block_3.sky130_hd_inv_1_1.Y sky130_hd_xor_block_3.XORB 0.165f
C1491 sky130_hd_ro32_nand_0.sky130_hd_inv_1_18.Y sky130_hd_ro32_nand_0.sky130_hd_inv_1_20.Y 5.04e-19
C1492 VDPWR sky130_hd_ro53_nand_0.sky130_hd_inv_1_39.Y 0.437f
C1493 sky130_hd_ro32_nand_0.sky130_hd_inv_1_3.Y sky130_hd_ro32_nand_0.sky130_hd_inv_1_1.Y 5.04e-19
C1494 sky130_hd_div_by_2_0.Qb a_28571_2435# 4.81e-19
C1495 sky130_hd_ro47_nand_0.sky130_hd_inv_1_22.Y sky130_hd_ro47_nand_0.sky130_hd_inv_1_23.Y 0.16f
C1496 VDPWR sky130_hd_div_by_2_1.CLK 0.507f
C1497 sky130_hd_div_by_2_0.Qb a_28340_2257# 6.6e-19
C1498 a_27631_2762# a_27392_2979# 0.0103f
C1499 a_8679_33959# sky130_hd_xor_block_3.XORB 6.09e-20
C1500 a_28256_3345# sky130_hd_div_by_2_3.Q 0.00877f
C1501 a_28544_2801# a_28324_2813# 4.62e-19
C1502 VDPWR sky130_hd_ro53_nand_0.sky130_hd_inv_1_9.Y 0.438f
C1503 a_27903_1579# a_27631_1674# 0.311f
C1504 sky130_hd_ro41_nand_0.sky130_hd_inv_1_36.Y sky130_hd_xor_block_2.XORB 0.00166f
C1505 sky130_hd_ro37_nand_0.sky130_hd_inv_1_31.Y sky130_hd_ro41_nand_0.sky130_hd_inv_1_32.Y 6.22e-19
C1506 a_27392_2979# a_27903_3755# 0.01f
C1507 sky130_hd_ro32_nand_0.sky130_hd_inv_1_22.Y ena 1.99e-19
C1508 sky130_hd_div_by_2_3.Qb a_28395_2712# 0.00267f
C1509 sky130_hd_div_by_2_0.Qb sky130_hd_div_by_2_3.Q 0.00109f
C1510 sky130_hd_xor_block_2.XORB sky130_hd_ro37_nand_0.sky130_hd_inv_1_11.Y 3.07e-19
C1511 a_28188_1565# a_27536_1321# 1.73e-20
C1512 sky130_hd_ro32_nand_0.sky130_hd_inv_1_21.Y sky130_hd_ro32_nand_0.sky130_hd_inv_1_19.Y 5.04e-19
C1513 sky130_hd_div_by_2_3.Qb a_27536_2409# 0.00257f
C1514 sky130_hd_div_by_2_0.Qb a_28742_1725# 0.00106f
C1515 sky130_hd_div_by_2_4.Q a_27746_2979# 0.0056f
C1516 VDPWR a_27926_3345# 0.00292f
C1517 a_28424_2159# sky130_hd_div_by_2_3.Q 4.17e-20
C1518 a_28742_1725# a_28424_2159# 5.32e-19
C1519 a_28424_3247# a_28324_2813# 7.11e-19
C1520 sky130_hd_ro32_nand_0.sky130_hd_inv_1_11.Y sky130_hd_ro32_nand_0.sky130_hd_inv_1_12.Y 0.16f
C1521 sky130_hd_ro32_nand_0.sky130_hd_inv_1_23.Y sky130_hd_ro32_nand_0.sky130_hd_inv_1_22.Y 0.16f
C1522 a_28256_2257# a_28188_1565# 2.74e-19
C1523 VDPWR sky130_hd_ro53_nand_0.sky130_hd_inv_1_27.Y 0.435f
C1524 a_28324_2813# a_28395_3800# 3.2e-20
C1525 a_28195_2557# sky130_hd_div_by_2_3.Q 0.0113f
C1526 sky130_hd_ro41_nand_0.sky130_hd_inv_1_1.A sky130_hd_xor_block_1.XORB 3.16e-19
C1527 sky130_hd_ro37_nand_0.sky130_hd_inv_1_9.Y sky130_hd_ro37_nand_0.sky130_hd_inv_1_10.Y 0.16f
C1528 sky130_hd_ro47_nand_0.sky130_hd_inv_1_34.Y sky130_hd_ro47_nand_0.sky130_hd_inv_1_35.A 5.04e-19
C1529 sky130_hd_xor_block_2.XORB sky130_hd_ro41_nand_0.sky130_hd_inv_1_18.Y 5.1e-19
C1530 sky130_hd_ro32_nand_0.sky130_hd_inv_1_1.Y a_27999_3091# 6.61e-23
C1531 a_27831_2257# sky130_hd_div_by_2_1.Qb 0.00258f
C1532 sky130_hd_ro37_nand_0.sky130_hd_inv_1_23.Y VDPWR 0.438f
C1533 a_27903_3755# a_28146_3523# 0.00851f
C1534 sky130_hd_ro33_nand_0.sky130_hd_inv_1_16.Y sky130_hd_ro33_nand_0.sky130_hd_inv_1_14.Y 5.04e-19
C1535 sky130_hd_ro41_nand_0.sky130_hd_inv_1_23.Y sky130_hd_ro37_nand_0.sky130_hd_inv_1_22.Y 6.22e-19
C1536 a_24259_35563# a_24123_35537# 0.141f
C1537 sky130_hd_div_by_2_1.Qb ua[0] 2.13e-19
C1538 sky130_hd_ro47_nand_0.sky130_hd_inv_1_28.Y sky130_hd_ro47_nand_0.sky130_hd_inv_1_27.Y 0.152f
C1539 a_24130_35837# sky130_hd_dfxtp_1_1.Q 0.0103f
C1540 sky130_hd_ro37_nand_0.sky130_hd_inv_1_30.Y sky130_hd_ro41_nand_0.sky130_hd_inv_1_31.Y 6.22e-19
C1541 a_27999_2003# a_28188_1565# 4.86e-19
C1542 a_27831_2257# a_27903_2667# 0.00138f
C1543 sky130_hd_ro47_nand_0.sky130_hd_inv_1_9.A sky130_hd_ro47_nand_0.sky130_hd_inv_1_11.A 5.04e-19
C1544 sky130_hd_ro33_nand_0.sky130_hd_inv_1_6.Y sky130_hd_ro33_nand_0.sky130_hd_inv_1_4.Y 5.04e-19
C1545 a_28571_1347# ua[1] 2.47e-19
C1546 sky130_hd_ro33_nand_0.sky130_hd_inv_1_10.Y sky130_hd_ro37_nand_0.sky130_hd_inv_1_10.Y 2.28e-19
C1547 a_28188_2653# ua[0] 9.76e-19
C1548 a_27903_1579# sky130_hd_div_by_2_1.CLK 8.67e-19
C1549 VDPWR sky130_hd_ro33_nand_0.sky130_hd_inv_1_2.Y 0.451f
C1550 sky130_hd_xor_block_2.XORB sky130_hd_ro41_nand_0.sky130_hd_inv_1_29.Y 5.1e-19
C1551 sky130_hd_xor_block_2.XORB sky130_hd_ro41_nand_0.sky130_hd_inv_1_32.Y 5.1e-19
C1552 VDPWR sky130_hd_div_by_2_1.Qb 0.392f
C1553 sky130_hd_xor_block_3.XORA sky130_hd_ro33_nand_0.sky130_hd_inv_1_24.Y 4.99e-19
C1554 sky130_hd_ro53_nand_0.sky130_hd_inv_1_42.Y sky130_hd_xor_block_0.XORB 7.87e-19
C1555 a_27558_2979# sky130_hd_ro32_nand_0.sky130_hd_inv_1_1.Y 2.01e-19
C1556 a_28195_3645# a_28324_2813# 8.47e-22
C1557 sky130_hd_ro32_nand_0.sky130_hd_inv_1_2.Y a_27392_2979# 3.64e-21
C1558 sky130_hd_ro53_nand_0.sky130_hd_inv_1_25.Y sky130_hd_ro53_nand_0.sky130_hd_inv_1_26.Y 0.16f
C1559 ui_in[5] a_7207_31915# 6.11e-20
C1560 sky130_hd_div_by_2_4.Q a_28855_3301# 3.79e-19
C1561 a_27631_3850# a_28195_3645# 0.0341f
C1562 sky130_hd_xor_block_0.XORB sky130_hd_ro53_nand_0.sky130_hd_inv_1_17.A 7.87e-19
C1563 a_28742_1725# a_28324_1725# 3.39e-19
C1564 sky130_hd_ro32_nand_0.sky130_hd_inv_1_6.Y sky130_hd_ro32_nand_0.sky130_hd_inv_1_8.Y 5.04e-19
C1565 sky130_hd_ro41_nand_0.sky130_hd_inv_1_29.Y sky130_hd_ro37_nand_0.sky130_hd_inv_1_27.Y 2.28e-19
C1566 VDPWR a_27903_2667# 0.187f
C1567 a_22936_31990# a_23186_31740# 0.00723f
C1568 sky130_hd_ro32_nand_0.sky130_hd_inv_1_10.Y ua[0] 0.011f
C1569 a_24259_35563# a_24479_35563# 4.62e-19
C1570 sky130_hd_ro41_nand_0.sky130_hd_inv_1_28.Y sky130_hd_ro41_nand_0.sky130_hd_inv_1_29.Y 0.16f
C1571 a_27392_1891# a_28324_2813# 4.32e-20
C1572 VDPWR sky130_hd_ro53_nand_0.sky130_hd_inv_1_15.A 0.487f
C1573 a_28188_2653# VDPWR 0.632f
C1574 a_27831_2257# a_27392_2979# 6.06e-21
C1575 a_22016_35929# clk 1.16e-19
C1576 sky130_hd_ro32_nand_0.sky130_hd_inv_1_26.Y sky130_hd_ro32_nand_0.sky130_hd_inv_1_28.Y 5.04e-19
C1577 a_28324_2813# a_28123_2801# 4.67e-20
C1578 sky130_hd_div_by_2_4.Q a_28742_3901# 2.87e-19
C1579 a_23839_35537# a_24081_35929# 0.00851f
C1580 a_27558_1891# a_28195_1469# 0.00464f
C1581 sky130_hd_ro33_nand_0.sky130_hd_inv_1_13.Y sky130_hd_ro37_nand_0.sky130_hd_inv_1_13.Y 6.23e-19
C1582 sky130_hd_ro37_nand_0.sky130_hd_inv_1_17.Y sky130_hd_xor_block_3.XORB 4.75e-19
C1583 sky130_hd_xor_block_0.XORB sky130_hd_ro47_nand_0.sky130_hd_inv_1_36.Y 3.86e-19
C1584 sky130_hd_ro33_nand_0.sky130_hd_inv_1_5.Y sky130_hd_xor_block_3.XORB 3.26e-19
C1585 a_27631_2762# sky130_hd_div_by_2_3.Q 6.36e-19
C1586 sky130_hd_ro32_nand_0.sky130_hd_inv_1_19.Y ua[0] 0.011f
C1587 sky130_hd_div_by_2_4.Q sky130_hd_ro32_nand_0.sky130_hd_inv_1_3.Y 7.29e-20
C1588 sky130_hd_ro53_nand_0.sky130_hd_nand2_1_0.Y a_2975_25393# 0.00964f
C1589 sky130_hd_ro37_nand_0.sky130_hd_inv_1_23.Y sky130_hd_ro33_nand_0.sky130_hd_inv_1_23.Y 6.23e-19
C1590 sky130_hd_inv_1_0.A clk 0.00812f
C1591 sky130_hd_xor_block_2.XORB sky130_hd_ro41_nand_0.sky130_hd_inv_1_3.A 5.1e-19
C1592 sky130_hd_xor_block_1.sky130_hd_xor2_1_0.A sky130_hd_xor_block_1.XOROUT 0.034f
C1593 sky130_hd_xor_block_1.XORB sky130_hd_ro47_nand_0.sky130_hd_inv_1_36.Y 6.56e-19
C1594 sky130_hd_ro32_nand_0.sky130_hd_inv_1_29.Y sky130_hd_ro32_nand_0.sky130_hd_inv_1_31.Y 5.04e-19
C1595 sky130_hd_xor_block_2.XORB sky130_hd_ro37_nand_0.sky130_hd_inv_1_19.Y 3.07e-19
C1596 VDPWR sky130_hd_ro32_nand_0.sky130_hd_inv_1_10.Y 0.417f
C1597 a_28382_2979# sky130_hd_div_by_2_2.Qb 6.33e-19
C1598 sky130_hd_ro37_nand_0.sky130_hd_inv_1_29.Y sky130_hd_ro41_nand_0.sky130_hd_inv_1_30.Y 2.28e-19
C1599 sky130_hd_ro53_nand_0.sky130_hd_inv_1_10.Y sky130_hd_xor_block_0.XORB 7.87e-19
C1600 a_7207_31915# sky130_hd_ro37_nand_0.sky130_hd_nand2_1_0.Y 0.00964f
C1601 VDPWR sky130_hd_ro41_nand_0.sky130_hd_inv_1_19.Y 0.503f
C1602 sky130_hd_ro33_nand_0.sky130_hd_inv_1_26.Y sky130_hd_ro33_nand_0.sky130_hd_inv_1_25.Y 0.16f
C1603 a_27926_2257# sky130_hd_div_by_2_2.Qb 4.95e-19
C1604 sky130_hd_ro47_nand_0.sky130_hd_inv_1_1.Y sky130_hd_ro47_nand_0.sky130_hd_inv_1_3.Y 5.04e-19
C1605 a_24950_30833# sky130_hd_xor_block_0.sky130_hd_xor2_1_0.A 4.43e-19
C1606 sky130_hd_ro33_nand_0.sky130_hd_inv_1_30.Y sky130_hd_xor_block_3.XORB 3.26e-19
C1607 a_28256_3345# a_28340_3345# 0.00851f
C1608 VDPWR a_27392_2979# 0.632f
C1609 sky130_hd_xor_block_0.XOROUT a_23839_35537# 8.94e-19
C1610 a_28188_3741# sky130_hd_div_by_2_4.Qb 0.111f
C1611 a_28188_3741# a_27536_3497# 1.73e-20
C1612 a_27903_1579# sky130_hd_div_by_2_1.Qb 0.028f
C1613 a_19695_33932# sky130_hd_xor_block_3.sky130_hd_xor2_1_0.A 0.0166f
C1614 VDPWR sky130_hd_ro37_nand_0.sky130_hd_inv_1_9.Y 0.438f
C1615 a_19445_33932# a_19527_33932# 0.00294f
C1616 sky130_hd_div_by_2_4.Q a_27999_3091# 0.00156f
C1617 sky130_hd_ro37_nand_0.sky130_hd_inv_1_14.Y sky130_hd_ro37_nand_0.sky130_hd_inv_1_15.Y 0.16f
C1618 VDPWR sky130_hd_ro32_nand_0.sky130_hd_inv_1_19.Y 0.419f
C1619 VDPWR sky130_hd_inv_4_0.A 0.566f
C1620 a_19695_33682# sky130_hd_xor_block_3.sky130_hd_xor2_1_0.A 0.00428f
C1621 sky130_hd_ro53_nand_0.sky130_hd_inv_1_38.Y sky130_hd_ro53_nand_0.sky130_hd_inv_1_39.Y 0.16f
C1622 sky130_hd_ro53_nand_0.sky130_hd_inv_1_7.Y sky130_hd_ro53_nand_0.sky130_hd_inv_1_9.Y 5.04e-19
C1623 sky130_hd_xor_block_2.sky130_hd_xor2_1_0.B sky130_hd_xor_block_2.sky130_hd_inv_1_3.A 0.16f
C1624 sky130_hd_ro41_nand_0.sky130_hd_inv_1_23.Y sky130_hd_ro41_nand_0.sky130_hd_inv_1_25.Y 5.04e-19
C1625 sky130_hd_ro41_nand_0.sky130_hd_inv_1_5.A sky130_hd_ro41_nand_0.sky130_hd_inv_1_7.A 5.04e-19
C1626 VDPWR sky130_hd_ro33_nand_0.sky130_hd_inv_1_20.Y 0.449f
C1627 sky130_hd_xor_block_2.XORB sky130_hd_ro37_nand_0.sky130_hd_inv_1_25.A 3.07e-19
C1628 VDPWR sky130_hd_ro53_nand_0.sky130_hd_inv_1_28.Y 0.437f
C1629 a_27392_1891# a_27558_1891# 0.975f
C1630 a_28188_1565# a_28395_2712# 6.06e-21
C1631 sky130_hd_xor_block_0.XOROUT a_24868_30833# 0.184f
C1632 a_27903_1579# a_27903_2667# 6.58e-19
C1633 sky130_hd_ro47_nand_0.sky130_hd_inv_1_31.Y sky130_hd_ro47_nand_0.sky130_hd_inv_1_30.Y 0.16f
C1634 a_27631_1674# a_28195_1469# 0.0341f
C1635 sky130_hd_ro41_nand_0.sky130_hd_inv_1_35.Y sky130_hd_ro41_nand_0.sky130_hd_inv_1_37.Y 5.04e-19
C1636 sky130_hd_ro47_nand_0.sky130_hd_inv_1_39.Y sky130_hd_ro47_nand_0.sky130_hd_inv_1_37.Y 5.04e-19
C1637 a_24330_35537# a_24123_35537# 0.273f
C1638 VDPWR a_28146_3523# 0.00464f
C1639 ui_in[7] sky130_hd_xor_block_0.XORB 0.405f
C1640 sky130_hd_ro47_nand_0.sky130_hd_inv_1_7.A sky130_hd_ro47_nand_0.sky130_hd_inv_1_19.Y 5.04e-19
C1641 VDPWR a_23018_31990# 0.00853f
C1642 sky130_hd_ro32_nand_0.sky130_hd_inv_1_9.Y ua[0] 0.011f
C1643 sky130_hd_ro37_nand_0.sky130_hd_inv_1_25.A sky130_hd_ro37_nand_0.sky130_hd_inv_1_27.Y 2.69e-19
C1644 sky130_hd_ro32_nand_0.sky130_hd_inv_1_13.Y ena 1.99e-19
C1645 sky130_hd_ro33_nand_0.sky130_hd_inv_1_10.Y VDPWR 0.437f
C1646 sky130_hd_xor_block_3.sky130_hd_inv_1_3.A sky130_hd_xor_block_3.sky130_hd_xor2_1_0.A 0.00398f
C1647 a_28324_3901# a_27392_2979# 4.32e-20
C1648 sky130_hd_ro47_nand_0.sky130_hd_inv_1_7.A sky130_hd_ro47_nand_0.sky130_hd_inv_1_8.A 0.157f
C1649 ua[0] sky130_hd_tapvpwrvgnd_1_6.VPWR 0.00214f
C1650 VDPWR sky130_hd_ro37_nand_0.sky130_hd_inv_1_1.A 0.478f
C1651 sky130_hd_ro37_nand_0.sky130_hd_inv_1_11.Y sky130_hd_ro37_nand_0.sky130_hd_inv_1_9.Y 5.04e-19
C1652 uo_out[0] a_22058_35537# 1.29e-20
C1653 sky130_hd_xor_block_3.XOROUT sky130_hd_xor_block_2.sky130_hd_xor2_1_0.A 0.00537f
C1654 a_23743_35715# a_22058_35537# 7.98e-20
C1655 sky130_hd_ro53_nand_0.sky130_hd_inv_1_19.A sky130_hd_ro53_nand_0.sky130_hd_inv_1_17.A 5.04e-19
C1656 a_22936_31990# VDPWR 0.255f
C1657 sky130_hd_ro47_nand_0.sky130_hd_inv_1_2.Y sky130_hd_ro47_nand_0.sky130_hd_inv_1_3.Y 0.16f
C1658 sky130_hd_ro41_nand_0.sky130_hd_inv_1_18.Y sky130_hd_ro41_nand_0.sky130_hd_inv_1_19.Y 0.16f
C1659 a_28424_3247# sky130_hd_div_by_2_1.CLK 9.37e-20
C1660 VDPWR sky130_hd_ro53_nand_0.sky130_hd_inv_1_36.Y 0.443f
C1661 sky130_hd_div_by_2_4.Q a_27558_2979# 0.0231f
C1662 sky130_hd_xor_block_3.XORA sky130_hd_ro33_nand_0.sky130_hd_nand2_1_0.Y 0.234f
C1663 VDPWR sky130_hd_dfxtp_1_1.Q 0.422f
C1664 sky130_hd_ro47_nand_0.sky130_hd_inv_1_8.A sky130_hd_ro47_nand_0.sky130_hd_inv_1_9.A 0.152f
C1665 a_24058_35563# a_23839_35537# 0.00617f
C1666 VDPWR sky130_hd_ro32_nand_0.sky130_hd_inv_1_9.Y 0.417f
C1667 sky130_hd_ro53_nand_0.sky130_hd_inv_1_47.Y sky130_hd_ro53_nand_0.sky130_hd_inv_1_48.Y 0.16f
C1668 a_27392_1891# a_27631_1674# 0.0103f
C1669 a_28324_3901# a_28146_3523# 9.73e-19
C1670 sky130_hd_xor_block_1.XORB sky130_hd_ro41_nand_0.sky130_hd_inv_1_39.Y 0.00181f
C1671 a_22194_35563# sky130_hd_dfxtp_1_1.Q 0.00317f
C1672 VDPWR sky130_hd_tapvpwrvgnd_1_6.VPWR 0.0123f
C1673 sky130_hd_div_by_2_2.Qb a_27536_3497# 1.75e-20
C1674 VDPWR sky130_hd_xor_block_0.XORB 5.63f
C1675 sky130_hd_ro47_nand_0.sky130_hd_inv_1_18.Y sky130_hd_ro47_nand_0.sky130_hd_inv_1_19.Y 0.16f
C1676 VDPWR sky130_hd_xor_block_1.XORB 4.58f
C1677 a_27392_1891# a_27746_1891# 0.0622f
C1678 sky130_hd_div_by_2_1.CLK a_28195_1469# 0.0113f
C1679 ua[0] sky130_hd_div_by_2_3.Q 0.0833f
C1680 a_24330_35537# a_24479_35563# 0.00553f
C1681 sky130_hd_ro41_nand_0.sky130_hd_inv_1_6.A sky130_hd_ro41_nand_0.sky130_hd_inv_1_7.A 0.16f
C1682 sky130_hd_xor_block_1.XORB sky130_hd_ro41_nand_0.sky130_hd_inv_1_8.A 3.16e-19
C1683 sky130_hd_xor_block_3.sky130_hd_inv_1_1.Y sky130_hd_xor_block_3.sky130_hd_xor2_1_0.B 5.97e-19
C1684 a_28742_1725# ua[0] 1.46e-19
C1685 a_22265_35537# a_22058_35537# 0.273f
C1686 sky130_hd_xor_block_3.XOROUT VDPWR 0.522f
C1687 sky130_hd_div_by_2_3.Qb a_28382_2979# 9.57e-19
C1688 sky130_hd_ro41_nand_0.sky130_hd_inv_1_10.A sky130_hd_xor_block_1.XORB 8.18e-19
C1689 sky130_hd_ro37_nand_0.sky130_hd_inv_1_14.Y VDPWR 0.439f
C1690 sky130_hd_ro47_nand_0.sky130_hd_inv_1_18.Y sky130_hd_ro47_nand_0.sky130_hd_inv_1_8.A 2.69e-19
C1691 VDPWR sky130_hd_ro33_nand_0.sky130_hd_inv_1_31.Y 0.46f
C1692 sky130_hd_xor_block_0.sky130_hd_inv_1_3.A a_24868_30833# 0.00265f
C1693 sky130_hd_ro32_nand_0.sky130_hd_inv_1_18.Y sky130_hd_ro32_nand_0.sky130_hd_inv_1_17.Y 0.16f
C1694 sky130_hd_ro53_nand_0.sky130_hd_inv_1_6.Y sky130_hd_ro53_nand_0.sky130_hd_inv_1_5.Y 0.152f
C1695 sky130_hd_tapvpwrvgnd_1_6.VPWR sky130_hd_ro32_nand_0.sky130_hd_inv_1_14.Y 0.00342f
C1696 VDPWR a_28571_2435# 0.00292f
C1697 VDPWR sky130_hd_ro37_nand_0.sky130_hd_inv_1_28.Y 0.443f
C1698 a_28340_2257# VDPWR 0.00464f
C1699 sky130_hd_ro53_nand_0.sky130_hd_nand2_1_0.Y sky130_hd_ro53_nand_0.sky130_hd_inv_1_48.Y 3.32e-19
C1700 a_25118_30583# sky130_hd_xor_block_0.sky130_hd_xor2_1_0.A 0.00428f
C1701 sky130_hd_ro41_nand_0.sky130_hd_inv_1_29.A sky130_hd_ro41_nand_0.sky130_hd_inv_1_31.Y 2.69e-19
C1702 a_27558_1891# a_28324_2813# 8.84e-20
C1703 sky130_hd_ro37_nand_0.sky130_hd_inv_1_14.Y sky130_hd_ro37_nand_0.sky130_hd_inv_1_12.Y 5.04e-19
C1704 sky130_hd_ro37_nand_0.sky130_hd_inv_1_22.Y sky130_hd_ro37_nand_0.sky130_hd_inv_1_24.Y 5.04e-19
C1705 VDPWR sky130_hd_xor_block_0.sky130_hd_xor2_1_0.B 0.533f
C1706 sky130_hd_ro33_nand_0.sky130_hd_inv_1_10.Y sky130_hd_ro33_nand_0.sky130_hd_inv_1_11.Y 0.16f
C1707 ui_in[7] sky130_hd_ro53_nand_0.sky130_hd_inv_1_49.Y 3.5e-19
C1708 VDPWR sky130_hd_div_by_2_3.Q 0.514f
C1709 a_27558_2979# sky130_hd_div_by_2_2.Q 1.57e-19
C1710 a_28742_1725# VDPWR 0.0754f
C1711 ui_in[5] ui_in[7] 6.19e-19
C1712 sky130_hd_ro41_nand_0.sky130_hd_inv_1_36.Y sky130_hd_xor_block_1.XORB 3.16e-19
C1713 sky130_hd_ro41_nand_0.sky130_hd_inv_1_33.Y sky130_hd_ro41_nand_0.sky130_hd_inv_1_35.Y 5.04e-19
C1714 sky130_hd_ro37_nand_0.sky130_hd_nand2_1_0.Y sky130_hd_ro37_nand_0.sky130_hd_inv_1_32.Y 3.32e-19
C1715 a_24259_35563# sky130_hd_dfxtp_1_1.Q 0.00358f
C1716 a_24123_35537# a_22058_35537# 1.32e-19
C1717 a_27831_3345# sky130_hd_ro32_nand_0.sky130_hd_inv_1_1.Y 4.46e-21
C1718 a_27392_1891# sky130_hd_div_by_2_1.CLK 0.00667f
C1719 a_21678_35715# a_22058_35537# 0.0487f
C1720 sky130_hd_ro37_nand_0.sky130_hd_inv_1_34.Y sky130_hd_ro37_nand_0.sky130_hd_inv_1_32.Y 5.04e-19
C1721 sky130_hd_xor_block_0.XOROUT a_25118_30833# 0.0751f
C1722 a_24677_35563# a_24123_35537# 0.0622f
C1723 VDPWR a_21993_35563# 4.56e-19
C1724 a_28544_1713# a_28195_1469# 0.00135f
C1725 a_21179_33268# sky130_hd_xor_block_3.sky130_hd_xor2_1_0.A 1.59e-19
C1726 sky130_hd_ro41_nand_0.sky130_hd_inv_1_24.Y sky130_hd_ro41_nand_0.sky130_hd_inv_1_26.Y 5.04e-19
C1727 sky130_hd_ro41_nand_0.sky130_hd_inv_1_18.Y sky130_hd_xor_block_1.XORB 3.16e-19
C1728 sky130_hd_ro37_nand_0.sky130_hd_inv_1_21.Y sky130_hd_ro37_nand_0.sky130_hd_inv_1_20.Y 0.16f
C1729 clk a_24130_35837# 0.0422f
C1730 a_21429_33018# a_21179_33268# 0.00723f
C1731 a_28256_3345# sky130_hd_ro32_nand_0.sky130_hd_inv_1_1.Y 5.23e-21
C1732 sky130_hd_ro37_nand_0.sky130_hd_nand2_1_0.Y sky130_hd_ro37_nand_0.sky130_hd_inv_1_33.Y 6.18e-19
C1733 a_27536_2409# a_27536_3497# 7.51e-19
C1734 sky130_hd_xor_block_2.XORB sky130_hd_ro37_nand_0.sky130_hd_inv_1_18.Y 3.07e-19
C1735 sky130_hd_ro41_nand_0.sky130_hd_inv_1_34.Y sky130_hd_ro37_nand_0.sky130_hd_inv_1_33.Y 6.22e-19
C1736 ui_in[4] sky130_hd_ro37_nand_0.sky130_hd_inv_1_32.Y 1.1e-20
C1737 ui_in[5] sky130_hd_ro41_nand_0.sky130_hd_inv_1_39.Y 9.39e-20
C1738 a_28188_2653# a_28424_3247# 0.0103f
C1739 a_28188_2653# a_28395_3800# 6.06e-21
C1740 VDPWR sky130_hd_ro53_nand_0.sky130_hd_inv_1_49.Y 0.428f
C1741 sky130_hd_div_by_2_1.Qb a_28195_1469# 0.298f
C1742 VDPWR sky130_hd_ro33_nand_0.sky130_hd_inv_1_12.Y 0.471f
C1743 a_21429_33018# sky130_hd_xor_block_2.XOROUT 0.00262f
C1744 a_22194_35563# a_21993_35563# 4.67e-20
C1745 sky130_hd_ro37_nand_0.sky130_hd_inv_1_34.Y sky130_hd_ro37_nand_0.sky130_hd_inv_1_33.Y 0.16f
C1746 sky130_hd_xor_block_2.XORB sky130_hd_ro37_nand_0.sky130_hd_inv_1_5.A 3.07e-19
C1747 ui_in[5] VDPWR 0.811f
C1748 sky130_hd_ro53_nand_0.sky130_hd_inv_1_31.Y sky130_hd_ro53_nand_0.sky130_hd_inv_1_33.Y 5.04e-19
C1749 ena sky130_hd_ro32_nand_0.sky130_hd_inv_1_5.Y 1.99e-19
C1750 sky130_hd_ro32_nand_0.sky130_hd_inv_1_25.Y ena 1.99e-19
C1751 sky130_hd_ro37_nand_0.sky130_hd_inv_1_6.A sky130_hd_ro41_nand_0.sky130_hd_inv_1_9.A 6.22e-19
C1752 sky130_hd_ro53_nand_0.sky130_hd_inv_1_4.Y sky130_hd_xor_block_0.XORB 0.0024f
C1753 sky130_hd_ro53_nand_0.sky130_hd_inv_1_31.Y sky130_hd_ro53_nand_0.sky130_hd_inv_1_30.Y 0.16f
C1754 sky130_hd_ro47_nand_0.sky130_hd_inv_1_21.Y sky130_hd_xor_block_0.XORB 3.86e-19
C1755 a_22065_35837# a_21774_35537# 0.197f
C1756 sky130_hd_ro47_nand_0.sky130_hd_inv_1_16.A sky130_hd_xor_block_0.XORB 3.86e-19
C1757 VDPWR sky130_hd_ro53_nand_0.sky130_hd_inv_1_19.A 0.446f
C1758 sky130_hd_ro33_nand_0.sky130_hd_inv_1_12.Y sky130_hd_ro37_nand_0.sky130_hd_inv_1_12.Y 2.28e-19
C1759 VDPWR sky130_hd_ro37_nand_0.sky130_hd_inv_1_3.A 0.516f
C1760 sky130_hd_ro47_nand_0.sky130_hd_inv_1_21.Y sky130_hd_xor_block_1.XORB 6.56e-19
C1761 VDPWR sky130_hd_ro33_nand_0.sky130_hd_inv_1_19.Y 0.472f
C1762 sky130_hd_div_by_2_3.Qb sky130_hd_div_by_2_4.Qb 0.0362f
C1763 sky130_hd_div_by_2_3.Qb a_27536_3497# 0.00166f
C1764 sky130_hd_ro47_nand_0.sky130_hd_inv_1_16.A sky130_hd_xor_block_1.XORB 6.56e-19
C1765 sky130_hd_xor_block_1.XORB sky130_hd_ro41_nand_0.sky130_hd_inv_1_32.Y 3.16e-19
C1766 sky130_hd_ro53_nand_0.sky130_hd_inv_1_51.Y sky130_hd_xor_block_0.XORB 0.0141f
C1767 sky130_hd_ro47_nand_0.sky130_hd_nand2_1_0.Y ui_in[6] 0.0771f
C1768 sky130_hd_ro32_nand_0.sky130_hd_inv_1_23.Y sky130_hd_ro32_nand_0.sky130_hd_inv_1_25.Y 5.04e-19
C1769 a_22194_35563# a_22414_35563# 4.62e-19
C1770 sky130_hd_xor_block_1.XORB sky130_hd_ro41_nand_0.sky130_hd_inv_1_29.Y 3.16e-19
C1771 ui_in[4] sky130_hd_ro37_nand_0.sky130_hd_inv_1_33.Y 3.2e-20
C1772 sky130_hd_ro41_nand_0.sky130_hd_nand2_1_0.Y sky130_hd_ro41_nand_0.sky130_hd_inv_1_39.Y 0.172f
C1773 a_28188_2653# a_28195_1469# 1.59e-19
C1774 sky130_hd_ro37_nand_0.sky130_hd_inv_1_4.A sky130_hd_ro37_nand_0.sky130_hd_inv_1_5.A 0.16f
C1775 sky130_hd_xor_block_3.XORA sky130_hd_ro33_nand_0.sky130_hd_inv_1_4.Y 0.00246f
C1776 sky130_hd_ro32_nand_0.sky130_hd_inv_1_29.Y sky130_hd_ro32_nand_0.sky130_hd_inv_1_28.Y 0.16f
C1777 sky130_hd_xor_block_3.XORB sky130_hd_ro37_nand_0.sky130_hd_inv_1_10.Y 4.75e-19
C1778 ua[1] sky130_hd_div_by_2_2.Q 0.00216f
C1779 a_28424_3247# a_27392_2979# 0.0486f
C1780 VDPWR sky130_hd_ro41_nand_0.sky130_hd_nand2_1_0.Y 0.411f
C1781 sky130_hd_ro53_nand_0.sky130_hd_inv_1_9.Y sky130_hd_ro53_nand_0.sky130_hd_inv_1_8.Y 0.16f
C1782 sky130_hd_ro33_nand_0.sky130_hd_inv_1_29.Y sky130_hd_ro37_nand_0.sky130_hd_inv_1_28.Y 2.28e-19
C1783 sky130_hd_ro33_nand_0.sky130_hd_inv_1_29.Y sky130_hd_ro33_nand_0.sky130_hd_inv_1_31.Y 5.04e-19
C1784 sky130_hd_xor_block_3.XORA sky130_hd_ro33_nand_0.sky130_hd_inv_1_28.Y 0.00165f
C1785 sky130_hd_ro37_nand_0.sky130_hd_inv_1_25.Y sky130_hd_ro41_nand_0.sky130_hd_inv_1_26.Y 6.22e-19
C1786 sky130_hd_ro53_nand_0.sky130_hd_inv_1_14.A sky130_hd_ro53_nand_0.sky130_hd_inv_1_13.A 0.157f
C1787 a_28855_2213# sky130_hd_div_by_2_2.Q 3.79e-19
C1788 a_27392_1891# sky130_hd_div_by_2_1.Qb 0.00247f
C1789 sky130_hd_ro41_nand_0.sky130_hd_inv_1_36.Y ui_in[5] 1.1e-20
C1790 a_28188_3741# a_28855_3301# 0.00737f
C1791 VDPWR sky130_hd_ro37_nand_0.sky130_hd_nand2_1_0.Y 0.42f
C1792 sky130_hd_ro41_nand_0.sky130_hd_inv_1_34.Y VDPWR 0.447f
C1793 sky130_hd_xor_block_3.XORA a_19695_33932# 9.97e-19
C1794 VDPWR sky130_hd_ro33_nand_0.sky130_hd_inv_1_1.Y 0.441f
C1795 a_28571_3523# VDPWR 0.00292f
C1796 a_27746_2979# sky130_hd_div_by_2_2.Qb 0.00103f
C1797 a_28188_2653# a_28195_3645# 6.29e-19
C1798 sky130_hd_ro33_nand_0.sky130_hd_inv_1_30.Y sky130_hd_ro37_nand_0.sky130_hd_inv_1_29.Y 2.28e-19
C1799 sky130_hd_ro53_nand_0.sky130_hd_inv_1_38.Y sky130_hd_ro53_nand_0.sky130_hd_inv_1_36.Y 5.04e-19
C1800 sky130_hd_ro37_nand_0.sky130_hd_inv_1_15.Y sky130_hd_xor_block_3.XORB 4.75e-19
C1801 sky130_hd_inv_1_0.A a_22441_35929# 9.91e-20
C1802 VDPWR sky130_hd_ro47_nand_0.sky130_hd_inv_1_20.Y 0.458f
C1803 VDPWR sky130_hd_ro37_nand_0.sky130_hd_inv_1_34.Y 0.442f
C1804 sky130_hd_xor_block_3.XORB sky130_hd_ro37_nand_0.sky130_hd_inv_1_32.Y 0.00163f
C1805 sky130_hd_ro53_nand_0.sky130_hd_inv_1_45.Y sky130_hd_ro53_nand_0.sky130_hd_inv_1_47.Y 5.04e-19
C1806 sky130_hd_xor_block_3.XORB sky130_hd_ro37_nand_0.sky130_hd_inv_1_21.Y 4.75e-19
C1807 a_27392_1891# a_27903_2667# 0.01f
C1808 a_27631_1674# a_27558_1891# 0.00175f
C1809 sky130_hd_ro32_nand_0.sky130_hd_inv_1_30.Y ena 6.38e-19
C1810 sky130_hd_ro37_nand_0.sky130_hd_inv_1_24.Y sky130_hd_ro41_nand_0.sky130_hd_inv_1_25.Y 6.22e-19
C1811 sky130_hd_ro53_nand_0.sky130_hd_inv_1_24.Y sky130_hd_ro53_nand_0.sky130_hd_inv_1_13.A 0.152f
C1812 sky130_hd_ro53_nand_0.sky130_hd_inv_1_7.Y sky130_hd_xor_block_0.XORB 7.87e-19
C1813 a_28188_3741# a_28742_3901# 0.0622f
C1814 a_28424_2159# a_28742_2813# 4.18e-19
C1815 ui_in[4] sky130_hd_ro41_nand_0.sky130_hd_inv_1_39.Y 2.7e-19
C1816 a_28188_2653# a_27392_1891# 0.00154f
C1817 VDPWR sky130_hd_ro37_nand_0.sky130_hd_inv_1_20.Y 0.447f
C1818 sky130_hd_ro53_nand_0.sky130_hd_inv_1_38.Y sky130_hd_xor_block_0.XORB 7.87e-19
C1819 a_27903_2667# a_28123_2801# 0.00617f
C1820 VDPWR sky130_hd_ro47_nand_0.sky130_hd_inv_1_24.Y 0.438f
C1821 sky130_hd_xor_block_1.XORB sky130_hd_ro41_nand_0.sky130_hd_inv_1_3.A 3.16e-19
C1822 a_24868_30833# sky130_hd_xor_block_1.XOROUT 5.22e-19
C1823 sky130_hd_ro41_nand_0.sky130_hd_inv_1_36.Y sky130_hd_ro41_nand_0.sky130_hd_nand2_1_0.Y 3.32e-19
C1824 sky130_hd_ro53_nand_0.sky130_hd_inv_1_18.A sky130_hd_ro53_nand_0.sky130_hd_inv_1_17.A 0.16f
C1825 VDPWR sky130_hd_ro47_nand_0.sky130_hd_inv_1_15.A 0.44f
C1826 sky130_hd_ro53_nand_0.sky130_hd_inv_1_15.A sky130_hd_ro53_nand_0.sky130_hd_inv_1_16.A 0.157f
C1827 sky130_hd_ro33_nand_0.sky130_hd_inv_1_12.Y sky130_hd_ro33_nand_0.sky130_hd_inv_1_11.Y 0.157f
C1828 sky130_hd_ro47_nand_0.sky130_hd_inv_1_29.Y sky130_hd_xor_block_0.XORB 3.86e-19
C1829 a_28742_2813# a_28195_2557# 0.0982f
C1830 sky130_hd_ro47_nand_0.sky130_hd_inv_1_29.Y sky130_hd_xor_block_1.XORB 6.56e-19
C1831 a_27558_1891# a_27746_1891# 0.0982f
C1832 VDPWR ui_in[4] 1f
C1833 sky130_hd_ro41_nand_0.sky130_hd_inv_1_34.Y sky130_hd_ro41_nand_0.sky130_hd_inv_1_36.Y 5.04e-19
C1834 sky130_hd_div_by_2_4.Q a_27831_3345# 0.00406f
C1835 sky130_hd_xor_block_0.sky130_hd_inv_1_1.Y sky130_hd_xor_block_0.XORB 0.165f
C1836 sky130_hd_ro32_nand_0.sky130_hd_inv_1_18.Y ena 1.99e-19
C1837 sky130_hd_xor_block_3.XORB sky130_hd_ro37_nand_0.sky130_hd_inv_1_33.Y 0.00235f
C1838 VDPWR a_28340_3345# 0.00464f
C1839 sky130_hd_xor_block_3.XORA sky130_hd_xor_block_3.sky130_hd_inv_1_3.A 0.166f
C1840 a_28256_2257# a_28395_1624# 0.00229f
C1841 sky130_hd_ro47_nand_0.sky130_hd_inv_1_43.Y sky130_hd_ro47_nand_0.sky130_hd_inv_1_42.Y 0.16f
C1842 a_24330_35537# sky130_hd_dfxtp_1_1.Q 0.00197f
C1843 a_28195_3645# a_27392_2979# 0.0113f
C1844 sky130_hd_ro41_nand_0.sky130_hd_inv_1_16.Y sky130_hd_ro41_nand_0.sky130_hd_inv_1_15.Y 0.16f
C1845 a_24123_35537# a_23743_35715# 0.0487f
C1846 uo_out[0] a_21678_35715# 9.85e-19
C1847 a_28188_3741# a_27999_3091# 4.32e-20
C1848 sky130_hd_xor_block_3.XOROUT a_19527_33932# 4.11e-20
C1849 sky130_hd_div_by_2_4.Q a_28256_3345# 0.00143f
C1850 sky130_hd_ro53_nand_0.sky130_hd_inv_1_51.Y sky130_hd_ro53_nand_0.sky130_hd_inv_1_49.Y 5.04e-19
C1851 a_27903_3755# sky130_hd_ro32_nand_0.sky130_hd_inv_1_1.Y 4.34e-20
C1852 sky130_hd_ro33_nand_0.sky130_hd_inv_1_7.Y sky130_hd_ro33_nand_0.sky130_hd_inv_1_8.Y 0.16f
C1853 VDPWR sky130_hd_ro41_nand_0.sky130_hd_inv_1_27.Y 0.435f
C1854 a_27392_1891# a_27392_2979# 0.00114f
C1855 a_23186_31990# sky130_hd_xor_block_2.XOROUT 3.3e-19
C1856 sky130_hd_xor_block_1.sky130_hd_xor2_1_0.A a_23186_31740# 0.00428f
C1857 sky130_hd_xor_block_2.XORB sky130_hd_ro37_nand_0.sky130_hd_inv_1_31.Y 3.07e-19
C1858 sky130_hd_ro41_nand_0.sky130_hd_inv_1_29.A sky130_hd_ro41_nand_0.sky130_hd_inv_1_30.Y 0.157f
C1859 sky130_hd_xor_block_0.sky130_hd_xor2_1_0.B sky130_hd_xor_block_0.sky130_hd_inv_1_1.Y 5.97e-19
C1860 a_28195_3645# a_28146_3523# 6.32e-19
C1861 sky130_hd_ro33_nand_0.sky130_hd_inv_1_9.Y VDPWR 0.438f
C1862 a_27558_1891# sky130_hd_div_by_2_1.CLK 0.00276f
C1863 sky130_hd_xor_block_3.XORA sky130_hd_ro33_nand_0.sky130_hd_inv_1_3.Y 0.00427f
C1864 sky130_hd_div_by_2_2.Qb a_28855_3301# 0.00271f
C1865 sky130_hd_ro37_nand_0.sky130_hd_inv_1_17.Y sky130_hd_ro37_nand_0.sky130_hd_inv_1_16.Y 0.157f
C1866 sky130_hd_ro33_nand_0.sky130_hd_inv_1_24.Y sky130_hd_ro33_nand_0.sky130_hd_inv_1_22.Y 5.04e-19
C1867 a_28544_2801# sky130_hd_div_by_2_3.Q 1.51e-19
C1868 a_27631_1674# a_27746_1891# 5.32e-19
C1869 sky130_hd_ro47_nand_0.sky130_hd_inv_1_40.Y sky130_hd_xor_block_0.XORB 3.86e-19
C1870 VDPWR clk 0.776f
C1871 a_27999_2003# a_27999_3091# 3.37e-19
C1872 sky130_hd_div_by_2_1.Qb a_28324_2813# 1.4e-21
C1873 sky130_hd_ro33_nand_0.sky130_hd_nand2_1_0.Y sky130_hd_ro33_nand_0.sky130_hd_inv_1_28.Y 3.32e-19
C1874 sky130_hd_xor_block_2.XORB sky130_hd_ro41_nand_0.sky130_hd_inv_1_13.Y 5.1e-19
C1875 sky130_hd_xor_block_1.XORB sky130_hd_ro47_nand_0.sky130_hd_inv_1_40.Y 6.56e-19
C1876 VDPWR sky130_hd_xor_block_3.XORB 3.29f
C1877 sky130_hd_ro53_nand_0.sky130_hd_inv_1_43.Y sky130_hd_ro53_nand_0.sky130_hd_inv_1_44.Y 0.16f
C1878 sky130_hd_ro53_nand_0.sky130_hd_inv_1_14.A sky130_hd_ro53_nand_0.sky130_hd_inv_1_24.Y 2.69e-19
C1879 sky130_hd_xor_block_3.XORA sky130_hd_ro33_nand_0.sky130_hd_inv_1_22.Y 4.99e-19
C1880 VDPWR a_28571_1347# 0.00293f
C1881 a_23186_31990# sky130_hd_xor_block_1.sky130_hd_xor2_1_0.B 0.057f
C1882 sky130_hd_inv_4_0.A a_22058_35537# 1.57e-20
C1883 sky130_hd_ro41_nand_0.sky130_hd_inv_1_34.Y sky130_hd_ro41_nand_0.sky130_hd_inv_1_32.Y 5.04e-19
C1884 ui_in[3] sky130_hd_ro33_nand_0.sky130_hd_inv_1_30.Y 5.12e-20
C1885 sky130_hd_ro47_nand_0.sky130_hd_inv_1_20.Y sky130_hd_ro47_nand_0.sky130_hd_inv_1_21.Y 0.16f
C1886 a_28424_3247# sky130_hd_div_by_2_3.Q 0.16f
C1887 sky130_hd_div_by_2_3.Q a_28395_3800# 0.00147f
C1888 a_19286_4740# sky130_hd_ro32_nand_0.sky130_hd_nand2_1_0.Y 0.00964f
C1889 a_22194_35563# clk 0.00142f
C1890 sky130_hd_ro37_nand_0.sky130_hd_inv_1_18.Y sky130_hd_ro41_nand_0.sky130_hd_inv_1_19.Y 2.28e-19
C1891 a_27746_2979# sky130_hd_div_by_2_3.Qb 0.147f
C1892 sky130_hd_ro41_nand_0.sky130_hd_inv_1_24.Y sky130_hd_ro41_nand_0.sky130_hd_inv_1_25.Y 0.16f
C1893 sky130_hd_div_by_2_4.Q sky130_hd_ro32_nand_0.sky130_hd_inv_1_4.Y 3.99e-19
C1894 sky130_hd_ro53_nand_0.sky130_hd_inv_1_48.Y sky130_hd_ro53_nand_0.sky130_hd_inv_1_50.Y 5.04e-19
C1895 sky130_hd_xor_block_3.XORB sky130_hd_ro37_nand_0.sky130_hd_inv_1_12.Y 4.75e-19
C1896 a_27558_2979# a_28188_3741# 0.0113f
C1897 a_27903_2667# a_28324_2813# 0.0368f
C1898 sky130_hd_xor_block_1.sky130_hd_inv_1_1.Y sky130_hd_xor_block_1.sky130_hd_inv_1_3.A 0.0274f
C1899 sky130_hd_ro33_nand_0.sky130_hd_inv_1_18.Y VDPWR 0.503f
C1900 sky130_hd_xor_block_3.sky130_hd_inv_1_1.Y sky130_hd_xor_block_3.sky130_hd_xor2_1_0.A 0.149f
C1901 sky130_hd_ro47_nand_0.sky130_hd_inv_1_36.Y sky130_hd_ro47_nand_0.sky130_hd_inv_1_35.A 0.157f
C1902 sky130_hd_xor_block_2.sky130_hd_xor2_1_0.B sky130_hd_xor_block_2.sky130_hd_xor2_1_0.A 0.315f
C1903 a_28188_2653# a_28324_2813# 0.141f
C1904 sky130_hd_ro37_nand_0.sky130_hd_inv_1_26.Y VDPWR 0.473f
C1905 a_27631_3850# a_27903_2667# 8.53e-20
C1906 a_22016_35929# a_21774_35537# 0.00851f
C1907 sky130_hd_div_by_2_0.Qb sky130_hd_div_by_2_2.Q 0.144f
C1908 VDPWR sky130_hd_ro53_nand_0.sky130_hd_inv_1_6.Y 0.451f
C1909 ena sky130_hd_ro32_nand_0.sky130_hd_nand2_1_0.Y 0.0831f
C1910 sky130_hd_ro47_nand_0.sky130_hd_inv_1_16.A sky130_hd_ro47_nand_0.sky130_hd_inv_1_15.A 0.16f
C1911 sky130_hd_ro37_nand_0.sky130_hd_inv_1_19.Y sky130_hd_ro33_nand_0.sky130_hd_inv_1_19.Y 2.28e-19
C1912 sky130_hd_xor_block_2.XORB a_19445_33932# 1e-19
C1913 a_27631_1674# sky130_hd_div_by_2_1.CLK 6.36e-19
C1914 sky130_hd_ro32_nand_0.sky130_hd_inv_1_11.Y ena 1.99e-19
C1915 sky130_hd_ro53_nand_0.sky130_hd_inv_1_2.Y sky130_hd_ro53_nand_0.sky130_hd_inv_1_3.Y 0.16f
C1916 a_28424_2159# sky130_hd_div_by_2_2.Q 0.00154f
C1917 sky130_hd_div_by_2_2.Qb a_27999_3091# 0.00279f
C1918 sky130_hd_ro47_nand_0.sky130_hd_inv_1_32.Y sky130_hd_ro47_nand_0.sky130_hd_inv_1_33.Y 0.16f
C1919 VDPWR sky130_hd_ro47_nand_0.sky130_hd_inv_1_13.A 0.437f
C1920 a_27999_2003# a_27957_1891# 4.62e-19
C1921 a_25118_30833# sky130_hd_xor_block_1.XOROUT 3.28e-19
C1922 sky130_hd_ro32_nand_0.sky130_hd_inv_1_2.Y sky130_hd_ro32_nand_0.sky130_hd_inv_1_1.Y 0.16f
C1923 sky130_hd_inv_1_0.A a_21774_35537# 0.0184f
C1924 a_28742_1725# a_28195_1469# 0.0982f
C1925 sky130_hd_xor_block_3.XORB sky130_hd_ro37_nand_0.sky130_hd_inv_1_11.Y 4.75e-19
C1926 sky130_hd_div_by_2_1.CLK a_27746_1891# 2.69e-19
C1927 sky130_hd_dfxtp_1_1.Q a_22058_35537# 0.104f
C1928 a_28195_2557# sky130_hd_div_by_2_2.Q 0.00229f
C1929 sky130_hd_ro53_nand_0.sky130_hd_inv_1_16.A sky130_hd_xor_block_0.XORB 7.87e-19
C1930 sky130_hd_ro37_nand_0.sky130_hd_inv_1_14.Y sky130_hd_ro33_nand_0.sky130_hd_inv_1_14.Y 6.23e-19
C1931 sky130_hd_xor_block_2.XORB sky130_hd_ro37_nand_0.sky130_hd_inv_1_27.Y 3.07e-19
C1932 VDPWR sky130_hd_ro53_nand_0.sky130_hd_inv_1_18.A 0.454f
C1933 sky130_hd_div_by_2_1.Qb a_27558_1891# 0.00132f
C1934 sky130_hd_ro33_nand_0.sky130_hd_inv_1_9.Y sky130_hd_ro33_nand_0.sky130_hd_inv_1_11.Y 5.04e-19
C1935 sky130_hd_xor_block_2.XORB sky130_hd_ro37_nand_0.sky130_hd_inv_1_4.A 3.07e-19
C1936 uio_in[1] uio_in[0] 0.031f
C1937 VDPWR sky130_hd_ro53_nand_0.sky130_hd_inv_1_26.Y 0.435f
C1938 sky130_hd_ro41_nand_0.sky130_hd_inv_1_12.Y sky130_hd_ro41_nand_0.sky130_hd_inv_1_1.A 0.152f
C1939 sky130_hd_xor_block_2.XORB sky130_hd_ro41_nand_0.sky130_hd_inv_1_28.Y 5.1e-19
C1940 a_24259_35563# clk 0.0102f
C1941 a_24677_35563# sky130_hd_dfxtp_1_1.Q 5.6e-19
C1942 a_27392_2979# a_28324_2813# 4.86e-19
C1943 sky130_hd_ro32_nand_0.sky130_hd_inv_1_10.Y sky130_hd_ro32_nand_0.sky130_hd_inv_1_8.Y 5.04e-19
C1944 a_28195_3645# sky130_hd_div_by_2_3.Q 0.007f
C1945 ua[0] sky130_hd_ro32_nand_0.sky130_hd_inv_1_1.Y 0.166f
C1946 VDPWR sky130_hd_xor_block_2.sky130_hd_xor2_1_0.B 0.537f
C1947 sky130_hd_xor_block_1.sky130_hd_xor2_1_0.A VDPWR 0.697f
C1948 sky130_hd_ro41_nand_0.sky130_hd_inv_1_27.Y sky130_hd_ro41_nand_0.sky130_hd_inv_1_29.Y 5.04e-19
C1949 a_27558_1891# a_27903_2667# 8.74e-20
C1950 a_27631_3850# a_27392_2979# 8.54e-19
C1951 sky130_hd_div_by_2_4.Q a_27631_2762# 9.37e-20
C1952 sky130_hd_xor_block_3.XORB sky130_hd_ro33_nand_0.sky130_hd_inv_1_11.Y 3.26e-19
C1953 VDPWR sky130_hd_ro47_nand_0.sky130_hd_inv_1_12.A 0.435f
C1954 ui_in[6] ui_in[7] 4.58f
C1955 sky130_hd_ro33_nand_0.sky130_hd_inv_1_5.Y sky130_hd_ro33_nand_0.sky130_hd_inv_1_6.Y 0.16f
C1956 sky130_hd_ro37_nand_0.sky130_hd_inv_1_19.Y sky130_hd_ro37_nand_0.sky130_hd_inv_1_20.Y 0.16f
C1957 sky130_hd_ro32_nand_0.sky130_hd_inv_1_3.Y ena 1.99e-19
C1958 a_28188_2653# a_27558_1891# 0.0113f
C1959 sky130_hd_div_by_2_4.Q a_27903_3755# 0.0084f
C1960 sky130_hd_ro33_nand_0.sky130_hd_inv_1_23.Y sky130_hd_xor_block_3.XORB 3.26e-19
C1961 sky130_hd_div_by_2_3.Qb a_28855_3301# 0.11f
C1962 a_28395_1624# a_28395_2712# 6.62e-19
C1963 sky130_hd_ro47_nand_0.sky130_hd_inv_1_31.Y VDPWR 0.45f
C1964 sky130_hd_ro47_nand_0.sky130_hd_inv_1_43.Y sky130_hd_ro47_nand_0.sky130_hd_inv_1_41.Y 5.04e-19
C1965 ua[1] a_27536_1321# 0.217f
C1966 a_21261_33268# sky130_hd_xor_block_2.sky130_hd_xor2_1_0.A 4.43e-19
C1967 sky130_hd_ro32_nand_0.sky130_hd_inv_1_17.Y sky130_hd_ro32_nand_0.sky130_hd_inv_1_16.Y 0.16f
C1968 a_27558_2979# sky130_hd_div_by_2_2.Qb 0.00174f
C1969 sky130_hd_ro53_nand_0.sky130_hd_inv_1_31.Y sky130_hd_xor_block_0.XORB 7.87e-19
C1970 sky130_hd_div_by_2_3.Q a_28123_2801# 6.39e-20
C1971 sky130_hd_xor_block_3.XORB sky130_hd_ro33_nand_0.sky130_hd_inv_1_29.Y 3.26e-19
C1972 sky130_hd_ro47_nand_0.sky130_hd_inv_1_43.Y sky130_hd_ro47_nand_0.sky130_hd_inv_1_44.Y 0.16f
C1973 sky130_hd_ro32_nand_0.sky130_hd_inv_1_20.Y sky130_hd_ro32_nand_0.sky130_hd_inv_1_21.Y 0.16f
C1974 VDPWR sky130_hd_ro32_nand_0.sky130_hd_inv_1_1.Y 0.418f
C1975 sky130_hd_ro37_nand_0.sky130_hd_inv_1_23.Y sky130_hd_xor_block_2.XORB 3.07e-19
C1976 sky130_hd_ro33_nand_0.sky130_hd_inv_1_26.Y sky130_hd_ro33_nand_0.sky130_hd_inv_1_24.Y 5.04e-19
C1977 sky130_hd_xor_block_0.XORB sky130_hd_xor_block_0.sky130_hd_xor2_1_0.A 0.0115f
C1978 sky130_hd_ro37_nand_0.sky130_hd_inv_1_8.Y sky130_hd_ro37_nand_0.sky130_hd_inv_1_10.Y 5.04e-19
C1979 a_28571_3523# a_28395_3800# 0.00772f
C1980 sky130_hd_xor_block_0.XORB sky130_hd_ro53_nand_0.sky130_hd_inv_1_8.Y 7.87e-19
C1981 a_27631_1674# sky130_hd_div_by_2_1.Qb 0.0494f
C1982 VDPWR sky130_hd_ro53_nand_0.sky130_hd_inv_1_37.Y 0.44f
C1983 VDPWR sky130_hd_ro47_nand_0.sky130_hd_inv_1_27.Y 0.471f
C1984 sky130_hd_ro41_nand_0.sky130_hd_inv_1_39.Y sky130_hd_ro41_nand_0.sky130_hd_inv_1_37.Y 5.04e-19
C1985 sky130_hd_xor_block_3.XORA sky130_hd_ro33_nand_0.sky130_hd_inv_1_26.Y 4.99e-19
C1986 sky130_hd_xor_block_2.sky130_hd_inv_1_3.A sky130_hd_xor_block_3.sky130_hd_xor2_1_0.A 4.68e-19
C1987 sky130_hd_ro33_nand_0.sky130_hd_inv_1_14.Y sky130_hd_ro33_nand_0.sky130_hd_inv_1_12.Y 5.04e-19
C1988 sky130_hd_xor_block_3.XOROUT a_21429_33268# 3.48e-19
C1989 sky130_hd_div_by_2_0.Qb a_28146_2435# 4.79e-19
C1990 sky130_hd_div_by_2_1.Qb a_27746_1891# 0.00103f
C1991 a_27558_1891# a_27392_2979# 6.29e-19
C1992 VDPWR sky130_hd_ro41_nand_0.sky130_hd_inv_1_37.Y 0.424f
C1993 VDPWR ui_in[6] 0.773f
C1994 sky130_hd_ro53_nand_0.sky130_hd_inv_1_6.Y sky130_hd_ro53_nand_0.sky130_hd_inv_1_4.Y 2.69e-19
C1995 VDPWR sky130_hd_ro47_nand_0.sky130_hd_inv_1_35.A 0.443f
C1996 sky130_hd_ro37_nand_0.sky130_hd_inv_1_2.A VDPWR 0.452f
C1997 a_27631_1674# a_27903_2667# 3.92e-20
C1998 sky130_hd_ro37_nand_0.sky130_hd_inv_1_21.Y sky130_hd_ro33_nand_0.sky130_hd_inv_1_21.Y 2.28e-19
C1999 a_28742_2813# ua[0] 1.46e-19
C2000 sky130_hd_ro47_nand_0.sky130_hd_inv_1_25.Y sky130_hd_xor_block_0.XORB 3.86e-19
C2001 sky130_hd_ro47_nand_0.sky130_hd_inv_1_16.Y sky130_hd_xor_block_0.XORB 3.86e-19
C2002 sky130_hd_ro41_nand_0.sky130_hd_inv_1_33.Y sky130_hd_ro37_nand_0.sky130_hd_inv_1_32.Y 6.22e-19
C2003 sky130_hd_ro47_nand_0.sky130_hd_inv_1_16.Y sky130_hd_xor_block_1.XORB 9.54e-19
C2004 a_21261_33268# VDPWR 0.00853f
C2005 sky130_hd_ro47_nand_0.sky130_hd_inv_1_25.Y sky130_hd_xor_block_1.XORB 6.56e-19
C2006 a_28195_2557# a_28146_2435# 6.32e-19
C2007 a_27631_2762# sky130_hd_div_by_2_2.Q 0.159f
C2008 sky130_hd_xor_block_0.sky130_hd_xor2_1_0.B sky130_hd_xor_block_0.sky130_hd_xor2_1_0.A 0.315f
C2009 uo_out[0] sky130_hd_inv_4_0.A 0.448f
C2010 ua[0] sky130_hd_ro32_nand_0.sky130_hd_inv_1_12.Y 0.011f
C2011 a_28324_3901# sky130_hd_ro32_nand_0.sky130_hd_inv_1_1.Y 5.92e-20
C2012 sky130_hd_ro47_nand_0.sky130_hd_inv_1_41.Y sky130_hd_ro47_nand_0.sky130_hd_inv_1_42.Y 0.16f
C2013 sky130_hd_ro32_nand_0.sky130_hd_inv_1_9.Y sky130_hd_ro32_nand_0.sky130_hd_inv_1_8.Y 0.16f
C2014 a_24130_35837# a_23839_35537# 0.197f
C2015 sky130_hd_ro53_nand_0.sky130_hd_inv_1_22.A VDPWR 0.437f
C2016 sky130_hd_div_by_2_3.Qb a_27999_3091# 0.0254f
C2017 sky130_hd_ro53_nand_0.sky130_hd_inv_1_10.Y sky130_hd_ro53_nand_0.sky130_hd_inv_1_22.Y 5.04e-19
C2018 sky130_hd_ro47_nand_0.sky130_hd_inv_1_44.Y sky130_hd_ro47_nand_0.sky130_hd_inv_1_42.Y 5.04e-19
C2019 a_28544_1713# sky130_hd_div_by_2_1.CLK 1.51e-19
C2020 a_27536_3497# sky130_hd_div_by_2_4.Qb 0.102f
C2021 sky130_hd_ro37_nand_0.sky130_hd_inv_1_19.Y sky130_hd_xor_block_3.XORB 4.75e-19
C2022 sky130_hd_ro53_nand_0.sky130_hd_inv_1_46.Y sky130_hd_xor_block_0.XORB 7.87e-19
C2023 sky130_hd_ro37_nand_0.sky130_hd_inv_1_25.A sky130_hd_ro41_nand_0.sky130_hd_inv_1_27.Y 6.22e-19
C2024 sky130_hd_xor_block_0.sky130_hd_xor2_1_0.B a_24950_30833# 0.014f
C2025 VDPWR a_28742_2813# 0.0754f
C2026 sky130_hd_ro33_nand_0.sky130_hd_inv_1_10.Y sky130_hd_ro33_nand_0.sky130_hd_inv_1_8.Y 5.04e-19
C2027 sky130_hd_ro41_nand_0.sky130_hd_inv_1_36.Y sky130_hd_ro41_nand_0.sky130_hd_inv_1_37.Y 0.16f
C2028 sky130_hd_ro47_nand_0.sky130_hd_inv_1_34.Y sky130_hd_ro47_nand_0.sky130_hd_inv_1_33.Y 0.16f
C2029 sky130_hd_div_by_2_1.Qb sky130_hd_div_by_2_1.CLK 0.138f
C2030 a_27558_2979# a_27536_2409# 6.08e-19
C2031 VDPWR sky130_hd_ro32_nand_0.sky130_hd_inv_1_12.Y 0.417f
C2032 a_28855_2213# sky130_hd_div_by_2_2.Qb 0.00166f
C2033 sky130_hd_ro32_nand_0.sky130_hd_inv_1_5.Y sky130_hd_div_by_2_4.Qb 2.62e-19
C2034 sky130_hd_ro32_nand_0.sky130_hd_inv_1_7.Y ena 1.99e-19
C2035 sky130_hd_ro41_nand_0.sky130_hd_inv_1_14.Y sky130_hd_ro37_nand_0.sky130_hd_inv_1_13.Y 6.22e-19
C2036 sky130_hd_div_by_2_3.Q a_28324_2813# 9.5e-19
C2037 sky130_hd_ro53_nand_0.sky130_hd_inv_1_7.Y sky130_hd_ro53_nand_0.sky130_hd_inv_1_6.Y 0.16f
C2038 uo_out[0] sky130_hd_dfxtp_1_1.Q 1.58e-20
C2039 a_23743_35715# sky130_hd_dfxtp_1_1.Q 0.135f
C2040 sky130_hd_div_by_2_4.Q ua[0] 1.61e-19
C2041 sky130_hd_ro47_nand_0.sky130_hd_inv_1_41.Y sky130_hd_ro47_nand_0.sky130_hd_inv_1_39.Y 5.04e-19
C2042 sky130_hd_ro37_nand_0.sky130_hd_inv_1_25.A sky130_hd_xor_block_3.XORB 4.75e-19
C2043 a_24330_35537# clk 0.0128f
C2044 a_28188_2653# sky130_hd_div_by_2_1.CLK 0.00748f
C2045 sky130_hd_xor_block_2.XORB sky130_hd_ro41_nand_0.sky130_hd_inv_1_19.Y 5.1e-19
C2046 VDPWR sky130_hd_ro47_nand_0.sky130_hd_inv_1_23.Y 0.439f
C2047 a_27558_2979# sky130_hd_div_by_2_3.Qb 0.3f
C2048 a_23186_31990# sky130_hd_xor_block_1.XOROUT 0.0712f
C2049 sky130_hd_ro32_nand_0.sky130_hd_inv_1_12.Y sky130_hd_ro32_nand_0.sky130_hd_inv_1_14.Y 5.04e-19
C2050 a_28123_3889# sky130_hd_div_by_2_3.Qb 1.95e-19
C2051 uio_in[2] uio_in[1] 0.031f
C2052 sky130_hd_ro32_nand_0.sky130_hd_inv_1_20.Y ua[0] 0.011f
C2053 sky130_hd_ro37_nand_0.sky130_hd_inv_1_17.Y sky130_hd_ro33_nand_0.sky130_hd_inv_1_17.Y 6.23e-19
C2054 sky130_hd_ro37_nand_0.sky130_hd_inv_1_5.A sky130_hd_ro37_nand_0.sky130_hd_inv_1_3.A 5.04e-19
C2055 sky130_hd_xor_block_2.XORB sky130_hd_ro37_nand_0.sky130_hd_inv_1_9.Y 3.07e-19
C2056 VDPWR sky130_hd_ro33_nand_0.sky130_hd_inv_1_21.Y 0.445f
C2057 sky130_hd_ro47_nand_0.sky130_hd_inv_1_38.Y sky130_hd_ro47_nand_0.sky130_hd_inv_1_36.Y 5.04e-19
C2058 sky130_hd_ro37_nand_0.sky130_hd_inv_1_25.A sky130_hd_ro37_nand_0.sky130_hd_inv_1_26.Y 0.157f
C2059 VDPWR sky130_hd_ro37_nand_0.sky130_hd_inv_1_8.Y 0.442f
C2060 sky130_hd_ro37_nand_0.sky130_hd_inv_1_30.Y sky130_hd_ro37_nand_0.sky130_hd_inv_1_32.Y 5.04e-19
C2061 VDPWR sky130_hd_ro37_nand_0.sky130_hd_inv_1_29.Y 0.45f
C2062 VDPWR sky130_hd_ro41_nand_0.sky130_hd_inv_1_33.Y 0.463f
C2063 sky130_hd_div_by_2_4.Q VDPWR 0.624f
C2064 a_21678_35715# sky130_hd_inv_4_0.A 2.85e-19
C2065 sky130_hd_ro33_nand_0.sky130_hd_nand2_1_0.Y sky130_hd_ro33_nand_0.sky130_hd_inv_1_26.Y 5.97e-20
C2066 a_28256_3345# a_28188_3741# 0.01f
C2067 sky130_hd_ro33_nand_0.sky130_hd_inv_1_4.Y sky130_hd_ro33_nand_0.sky130_hd_inv_1_3.Y 0.16f
C2068 sky130_hd_div_by_2_1.Qb a_28544_1713# 0.00167f
C2069 VDPWR sky130_hd_ro41_nand_0.sky130_hd_inv_1_23.Y 0.439f
C2070 sky130_hd_ro37_nand_0.sky130_hd_inv_1_15.Y sky130_hd_ro37_nand_0.sky130_hd_inv_1_16.Y 0.16f
C2071 sky130_hd_div_by_2_0.Qb a_27536_1321# 0.00258f
C2072 a_22265_35537# sky130_hd_dfxtp_1_1.Q 0.0032f
C2073 a_28340_2257# a_27558_1891# 6.32e-19
C2074 VDPWR sky130_hd_ro33_nand_0.sky130_hd_inv_1_13.Y 0.44f
C2075 a_28256_2257# a_28256_3345# 6.58e-19
C2076 VDPWR a_22441_35929# 0.00292f
C2077 sky130_hd_ro32_nand_0.sky130_hd_inv_1_16.Y ena 1.99e-19
C2078 sky130_hd_xor_block_3.XORA sky130_hd_xor_block_3.sky130_hd_inv_1_1.Y 5.97e-19
C2079 VDPWR sky130_hd_xor_block_3.sky130_hd_xor2_1_0.B 0.531f
C2080 a_27999_2003# a_27831_3345# 5.81e-20
C2081 a_27831_2257# sky130_hd_div_by_2_2.Q 0.00406f
C2082 sky130_hd_ro32_nand_0.sky130_hd_inv_1_20.Y VDPWR 0.419f
C2083 sky130_hd_ro32_nand_0.sky130_hd_inv_1_11.Y sky130_hd_ro32_nand_0.sky130_hd_inv_1_13.Y 5.04e-19
C2084 sky130_hd_div_by_2_0.Qb a_28256_2257# 0.0282f
C2085 sky130_hd_xor_block_2.XOROUT sky130_hd_xor_block_2.sky130_hd_inv_1_1.Y 0.00108f
C2086 VDPWR sky130_hd_ro53_nand_0.sky130_hd_inv_1_22.Y 0.435f
C2087 sky130_hd_ro53_nand_0.sky130_hd_nand2_1_0.Y ui_in[7] 0.0903f
C2088 a_28424_2159# a_28256_2257# 0.311f
C2089 a_28188_3741# a_28195_2557# 1.59e-19
C2090 sky130_hd_ro47_nand_0.sky130_hd_inv_1_29.Y sky130_hd_ro47_nand_0.sky130_hd_inv_1_31.Y 5.04e-19
C2091 sky130_hd_ro32_nand_0.sky130_hd_inv_1_23.Y sky130_hd_tapvpwrvgnd_1_7.VPWR 0.00342f
C2092 sky130_hd_ro53_nand_0.sky130_hd_inv_1_30.Y sky130_hd_ro53_nand_0.sky130_hd_inv_1_28.Y 5.04e-19
C2093 sky130_hd_ro37_nand_0.sky130_hd_inv_1_18.Y sky130_hd_ro37_nand_0.sky130_hd_inv_1_20.Y 5.04e-19
C2094 sky130_hd_xor_block_2.XORB sky130_hd_ro37_nand_0.sky130_hd_inv_1_1.A 3.07e-19
C2095 sky130_hd_xor_block_1.XORB sky130_hd_ro41_nand_0.sky130_hd_inv_1_13.Y 3.16e-19
C2096 VDPWR sky130_hd_ro53_nand_0.sky130_hd_inv_1_47.Y 0.471f
C2097 a_28256_2257# a_28195_2557# 8.74e-20
C2098 a_22936_31990# sky130_hd_xor_block_1.sky130_hd_inv_1_3.A 0.00265f
C2099 sky130_hd_ro47_nand_0.sky130_hd_inv_1_45.Y sky130_hd_xor_block_0.XORB 0.00192f
C2100 VDPWR sky130_hd_ro33_nand_0.sky130_hd_inv_1_25.Y 0.435f
C2101 sky130_hd_ro41_nand_0.sky130_hd_inv_1_12.Y VDPWR 0.437f
C2102 a_27926_3345# a_27392_2979# 0.0027f
C2103 sky130_hd_xor_block_0.XORB sky130_hd_ro53_nand_0.sky130_hd_inv_1_1.Y 0.164f
C2104 sky130_hd_ro47_nand_0.sky130_hd_inv_1_45.Y sky130_hd_xor_block_1.XORB 0.0139f
C2105 sky130_hd_div_by_2_1.Qb a_27903_2667# 7.96e-21
C2106 sky130_hd_ro53_nand_0.sky130_hd_inv_1_45.Y sky130_hd_ro53_nand_0.sky130_hd_inv_1_43.Y 5.04e-19
C2107 a_24123_35537# sky130_hd_dfxtp_1_1.Q 0.00779f
C2108 sky130_hd_xor_block_3.XORB sky130_hd_ro33_nand_0.sky130_hd_inv_1_14.Y 3.26e-19
C2109 sky130_hd_div_by_2_4.Q a_28324_3901# 0.00112f
C2110 sky130_hd_ro41_nand_0.sky130_hd_inv_1_20.Y sky130_hd_ro41_nand_0.sky130_hd_inv_1_22.Y 2.69e-19
C2111 sky130_hd_div_by_2_0.Qb a_27999_2003# 0.0273f
C2112 sky130_hd_ro53_nand_0.sky130_hd_inv_1_38.Y sky130_hd_ro53_nand_0.sky130_hd_inv_1_37.Y 0.16f
C2113 sky130_hd_xor_block_0.XORB sky130_hd_ro47_nand_0.sky130_hd_inv_1_35.Y 3.86e-19
C2114 a_28188_2653# sky130_hd_div_by_2_1.Qb 2.28e-20
C2115 a_21678_35715# sky130_hd_dfxtp_1_1.Q 7.42e-19
C2116 sky130_hd_xor_block_0.XORB sky130_hd_ro53_nand_0.sky130_hd_inv_1_41.A 7.87e-19
C2117 sky130_hd_ro33_nand_0.sky130_hd_inv_1_7.Y sky130_hd_ro37_nand_0.sky130_hd_inv_1_1.A 6.23e-19
C2118 a_28424_2159# a_27999_2003# 1.28e-19
C2119 sky130_hd_xor_block_1.XORB sky130_hd_ro47_nand_0.sky130_hd_inv_1_35.Y 6.56e-19
C2120 sky130_hd_xor_block_1.sky130_hd_inv_1_1.Y sky130_hd_xor_block_1.XORB 0.165f
C2121 sky130_hd_ro47_nand_0.sky130_hd_inv_1_29.Y sky130_hd_ro47_nand_0.sky130_hd_inv_1_27.Y 5.04e-19
C2122 sky130_hd_ro41_nand_0.sky130_hd_inv_1_2.A sky130_hd_ro41_nand_0.sky130_hd_inv_1_4.A 2.69e-19
C2123 sky130_hd_ro47_nand_0.sky130_hd_inv_1_10.A sky130_hd_ro47_nand_0.sky130_hd_inv_1_11.A 0.16f
C2124 sky130_hd_xor_block_0.sky130_hd_xor2_1_0.B a_25118_30583# 8.18e-19
C2125 VDPWR sky130_hd_div_by_2_2.Q 0.623f
C2126 a_27831_3345# sky130_hd_div_by_2_2.Qb 0.00284f
C2127 sky130_hd_ro47_nand_0.sky130_hd_inv_1_7.A VDPWR 0.486f
C2128 sky130_hd_div_by_2_3.Qb a_28855_2213# 1.72e-20
C2129 a_28188_1565# a_28395_1624# 0.273f
C2130 a_22612_35563# a_22065_35837# 0.102f
C2131 sky130_hd_ro53_nand_0.sky130_hd_inv_1_27.Y sky130_hd_ro53_nand_0.sky130_hd_inv_1_28.Y 0.16f
C2132 a_27999_2003# a_28195_2557# 8.84e-20
C2133 sky130_hd_xor_block_1.XORB sky130_hd_xor_block_1.sky130_hd_inv_1_3.A 5.97e-19
C2134 sky130_hd_ro47_nand_0.sky130_hd_inv_1_25.Y sky130_hd_ro47_nand_0.sky130_hd_inv_1_24.Y 0.16f
C2135 a_28188_2653# a_27903_2667# 0.0322f
C2136 sky130_hd_xor_block_2.XORB sky130_hd_xor_block_1.XORB 0.0318f
C2137 clk a_22058_35537# 0.254f
C2138 sky130_hd_ro47_nand_0.sky130_hd_inv_1_16.Y sky130_hd_ro47_nand_0.sky130_hd_inv_1_15.A 5.04e-19
C2139 VDPWR sky130_hd_ro53_nand_0.sky130_hd_nand2_1_0.Y 0.413f
C2140 sky130_hd_ro47_nand_0.sky130_hd_inv_1_26.Y sky130_hd_ro47_nand_0.sky130_hd_inv_1_28.Y 2.69e-19
C2141 sky130_hd_ro47_nand_0.sky130_hd_inv_1_23.Y sky130_hd_ro47_nand_0.sky130_hd_inv_1_21.Y 5.04e-19
C2142 VDPWR sky130_hd_ro47_nand_0.sky130_hd_inv_1_9.A 0.474f
C2143 uo_out[0] ui_in[5] 0.183f
C2144 VDPWR a_23839_35537# 0.185f
C2145 uio_in[6] uio_in[5] 0.031f
C2146 sky130_hd_xor_block_3.XOROUT a_19445_33932# 0.182f
C2147 sky130_hd_xor_block_2.XORB sky130_hd_xor_block_3.XOROUT 0.0409f
C2148 sky130_hd_ro33_nand_0.sky130_hd_inv_1_23.Y sky130_hd_ro33_nand_0.sky130_hd_inv_1_21.Y 2.69e-19
C2149 sky130_hd_ro53_nand_0.sky130_hd_inv_1_33.Y sky130_hd_xor_block_0.XORB 7.87e-19
C2150 sky130_hd_ro41_nand_0.sky130_hd_inv_1_12.Y sky130_hd_ro37_nand_0.sky130_hd_inv_1_11.Y 6.22e-19
C2151 sky130_hd_ro37_nand_0.sky130_hd_inv_1_14.Y sky130_hd_xor_block_2.XORB 3.07e-19
C2152 a_28256_3345# sky130_hd_div_by_2_2.Qb 0.0034f
C2153 sky130_hd_ro37_nand_0.sky130_hd_inv_1_30.Y VDPWR 0.475f
C2154 sky130_hd_ro33_nand_0.sky130_hd_inv_1_13.Y sky130_hd_ro33_nand_0.sky130_hd_inv_1_11.Y 2.69e-19
C2155 clk a_24677_35563# 0.00662f
C2156 sky130_hd_ro53_nand_0.sky130_hd_inv_1_30.Y sky130_hd_xor_block_0.XORB 7.87e-19
C2157 sky130_hd_div_by_2_0.Qb sky130_hd_div_by_2_2.Qb 0.0498f
C2158 sky130_hd_xor_block_2.XORB sky130_hd_ro37_nand_0.sky130_hd_inv_1_28.Y 3.07e-19
C2159 a_28256_2257# a_28324_1725# 0.00273f
C2160 sky130_hd_xor_block_0.XORB sky130_hd_ro53_nand_0.sky130_hd_inv_1_39.Y 7.87e-19
C2161 VDPWR sky130_hd_ro47_nand_0.sky130_hd_inv_1_38.Y 0.435f
C2162 VDPWR sky130_hd_ro41_nand_0.sky130_hd_inv_1_7.A 0.5f
C2163 a_28424_2159# sky130_hd_div_by_2_2.Qb 0.00888f
C2164 sky130_hd_ro41_nand_0.sky130_hd_inv_1_28.Y sky130_hd_xor_block_1.XORB 3.16e-19
C2165 VDPWR sky130_hd_ro37_nand_0.sky130_hd_inv_1_16.Y 0.45f
C2166 VDPWR ui_in[3] 1.36f
C2167 sky130_hd_ro53_nand_0.sky130_hd_inv_1_9.Y sky130_hd_xor_block_0.XORB 7.87e-19
C2168 sky130_hd_ro41_nand_0.sky130_hd_inv_1_33.Y sky130_hd_ro41_nand_0.sky130_hd_inv_1_32.Y 0.16f
C2169 sky130_hd_ro41_nand_0.sky130_hd_inv_1_8.A sky130_hd_ro41_nand_0.sky130_hd_inv_1_7.A 0.16f
C2170 a_24479_35563# sky130_hd_dfxtp_1_1.Q 2.16e-19
C2171 sky130_hd_ro41_nand_0.sky130_hd_inv_1_20.Y sky130_hd_ro41_nand_0.sky130_hd_inv_1_21.Y 0.157f
C2172 VDPWR a_24868_30833# 0.254f
C2173 sky130_hd_ro33_nand_0.sky130_hd_inv_1_16.Y sky130_hd_xor_block_3.XORB 3.26e-19
C2174 a_28195_2557# sky130_hd_div_by_2_2.Qb 0.297f
C2175 sky130_hd_ro37_nand_0.sky130_hd_inv_1_18.Y sky130_hd_xor_block_3.XORB 4.75e-19
C2176 VDPWR sky130_hd_ro47_nand_0.sky130_hd_inv_1_18.Y 0.483f
C2177 a_27903_2667# a_27392_2979# 2.74e-19
C2178 VDPWR sky130_hd_ro53_nand_0.sky130_hd_inv_1_21.A 0.439f
C2179 sky130_hd_ro53_nand_0.sky130_hd_inv_1_18.A sky130_hd_ro53_nand_0.sky130_hd_inv_1_16.A 5.04e-19
C2180 sky130_hd_ro37_nand_0.sky130_hd_inv_1_28.Y sky130_hd_ro37_nand_0.sky130_hd_inv_1_27.Y 0.16f
C2181 sky130_hd_xor_block_3.XORB sky130_hd_ro37_nand_0.sky130_hd_inv_1_5.A 0.0047f
C2182 a_28382_2979# a_27999_3091# 4.67e-20
C2183 VDPWR sky130_hd_ro41_nand_0.sky130_hd_inv_1_15.Y 0.439f
C2184 a_28188_2653# a_27392_2979# 0.00247f
C2185 sky130_hd_xor_block_0.XORB sky130_hd_ro53_nand_0.sky130_hd_inv_1_27.Y 7.87e-19
C2186 sky130_hd_ro33_nand_0.sky130_hd_inv_1_23.Y sky130_hd_ro33_nand_0.sky130_hd_inv_1_25.Y 5.04e-19
C2187 a_22265_35537# a_22414_35563# 0.00553f
C2188 sky130_hd_ro33_nand_0.sky130_hd_inv_1_16.Y sky130_hd_ro33_nand_0.sky130_hd_inv_1_18.Y 5.04e-19
C2189 sky130_hd_ro53_nand_0.sky130_hd_inv_1_3.Y sky130_hd_ro53_nand_0.sky130_hd_inv_1_5.Y 5.04e-19
C2190 sky130_hd_ro33_nand_0.sky130_hd_nand2_1_0.Y a_8679_33959# 0.00964f
C2191 a_28188_3741# a_27903_3755# 0.0322f
C2192 a_28340_2257# sky130_hd_div_by_2_1.CLK 4.41e-19
C2193 sky130_hd_ro33_nand_0.sky130_hd_inv_1_18.Y sky130_hd_ro37_nand_0.sky130_hd_inv_1_18.Y 2.28e-19
C2194 sky130_hd_ro53_nand_0.sky130_hd_inv_1_25.Y sky130_hd_ro53_nand_0.sky130_hd_inv_1_13.A 5.04e-19
C2195 sky130_hd_xor_block_3.XORA sky130_hd_ro33_nand_0.sky130_hd_inv_1_5.Y 0.00154f
C2196 sky130_hd_div_by_2_1.CLK sky130_hd_div_by_2_3.Q 0.0473f
C2197 a_28195_3645# sky130_hd_ro32_nand_0.sky130_hd_inv_1_1.Y 0.00123f
C2198 sky130_hd_ro41_nand_0.sky130_hd_inv_1_16.Y sky130_hd_ro41_nand_0.sky130_hd_inv_1_14.Y 5.04e-19
C2199 sky130_hd_ro37_nand_0.sky130_hd_nand2_1_0.Y sky130_hd_ro37_nand_0.sky130_hd_inv_1_31.Y 2.03e-19
C2200 a_21678_35715# a_21993_35563# 7.84e-20
C2201 a_28742_1725# sky130_hd_div_by_2_1.CLK 0.00161f
C2202 a_28424_3247# a_28742_2813# 5.32e-19
C2203 VDPWR sky130_hd_ro53_nand_0.sky130_hd_inv_1_20.A 0.441f
C2204 sky130_hd_ro33_nand_0.sky130_hd_inv_1_26.Y sky130_hd_ro33_nand_0.sky130_hd_inv_1_28.Y 5.04e-19
C2205 sky130_hd_ro53_nand_0.sky130_hd_inv_1_6.Y sky130_hd_ro53_nand_0.sky130_hd_inv_1_8.Y 5.04e-19
C2206 VDPWR a_28146_2435# 0.00464f
C2207 VDPWR a_21774_35537# 0.19f
C2208 a_24259_35563# a_23839_35537# 0.0368f
C2209 a_28855_3301# sky130_hd_div_by_2_4.Qb 0.00169f
C2210 uo_out[0] ui_in[4] 0.183f
C2211 sky130_hd_xor_block_3.XORB sky130_hd_ro33_nand_0.sky130_hd_inv_1_27.Y 3.26e-19
C2212 sky130_hd_xor_block_2.XORB ui_in[5] 0.37f
C2213 a_27999_2003# a_27631_2762# 5.95e-19
C2214 sky130_hd_ro47_nand_0.sky130_hd_inv_1_2.Y sky130_hd_ro47_nand_0.sky130_hd_inv_1_4.Y 5.04e-19
C2215 a_27926_3345# sky130_hd_div_by_2_3.Q 2.47e-19
C2216 a_28256_3345# a_28395_2712# 0.00229f
C2217 sky130_hd_xor_block_3.XORA sky130_hd_ro33_nand_0.sky130_hd_inv_1_30.Y 0.00404f
C2218 sky130_hd_div_by_2_0.Qb a_28395_2712# 0.00248f
C2219 sky130_hd_xor_block_2.XORB sky130_hd_ro37_nand_0.sky130_hd_inv_1_3.A 3.07e-19
C2220 a_22194_35563# a_21774_35537# 0.0368f
C2221 sky130_hd_div_by_2_0.Qb a_27536_2409# 0.00166f
C2222 sky130_hd_div_by_2_3.Qb a_28544_3889# 2.94e-19
C2223 a_28424_2159# a_28395_2712# 0.00875f
C2224 a_28742_3901# sky130_hd_div_by_2_4.Qb 0.147f
C2225 sky130_hd_div_by_2_3.Qb a_27831_3345# 0.0211f
C2226 sky130_hd_ro37_nand_0.sky130_hd_inv_1_26.Y sky130_hd_ro33_nand_0.sky130_hd_inv_1_27.Y 6.23e-19
C2227 sky130_hd_ro32_nand_0.sky130_hd_inv_1_3.Y sky130_hd_div_by_2_4.Qb 0.00408f
C2228 sky130_hd_ro32_nand_0.sky130_hd_inv_1_3.Y a_27536_3497# 6.67e-20
C2229 a_28195_2557# a_28395_2712# 0.083f
C2230 sky130_hd_ro53_nand_0.sky130_hd_inv_1_51.Y sky130_hd_ro53_nand_0.sky130_hd_nand2_1_0.Y 0.172f
C2231 sky130_hd_xor_block_2.sky130_hd_xor2_1_0.B a_21429_33268# 0.057f
C2232 a_28195_2557# a_27536_2409# 2.25e-19
C2233 sky130_hd_xor_block_2.XORB sky130_hd_ro41_nand_0.sky130_hd_nand2_1_0.Y 0.234f
C2234 sky130_hd_ro33_nand_0.sky130_hd_inv_1_15.Y sky130_hd_ro37_nand_0.sky130_hd_inv_1_15.Y 6.23e-19
C2235 sky130_hd_ro33_nand_0.sky130_hd_inv_1_9.Y sky130_hd_ro33_nand_0.sky130_hd_inv_1_8.Y 0.16f
C2236 a_28256_3345# sky130_hd_div_by_2_3.Qb 0.0283f
C2237 sky130_hd_ro37_nand_0.sky130_hd_inv_1_4.A sky130_hd_ro37_nand_0.sky130_hd_inv_1_3.A 0.157f
C2238 sky130_hd_ro32_nand_0.sky130_hd_inv_1_3.Y sky130_hd_ro32_nand_0.sky130_hd_inv_1_5.Y 5.04e-19
C2239 ui_in[3] sky130_hd_ro33_nand_0.sky130_hd_inv_1_29.Y 3.2e-20
C2240 sky130_hd_xor_block_3.sky130_hd_xor2_1_0.B a_19527_33932# 0.014f
C2241 sky130_hd_ro33_nand_0.sky130_hd_inv_1_22.Y sky130_hd_ro37_nand_0.sky130_hd_inv_1_22.Y 2.28e-19
C2242 VDPWR sky130_hd_ro33_nand_0.sky130_hd_inv_1_6.Y 0.448f
C2243 sky130_hd_ro53_nand_0.sky130_hd_inv_1_15.A sky130_hd_xor_block_0.XORB 7.87e-19
C2244 a_27631_2762# sky130_hd_div_by_2_2.Qb 0.0494f
C2245 sky130_hd_div_by_2_4.Q a_28424_3247# 0.00154f
C2246 sky130_hd_ro41_nand_0.sky130_hd_inv_1_34.Y sky130_hd_xor_block_2.XORB 5.1e-19
C2247 sky130_hd_xor_block_2.XORB sky130_hd_ro37_nand_0.sky130_hd_nand2_1_0.Y 0.0015f
C2248 sky130_hd_div_by_2_4.Q a_28395_3800# 0.0011f
C2249 a_19445_33932# sky130_hd_ro33_nand_0.sky130_hd_inv_1_1.Y 1.46e-20
C2250 sky130_hd_ro47_nand_0.sky130_hd_inv_1_8.A sky130_hd_ro47_nand_0.sky130_hd_inv_1_10.A 2.69e-19
C2251 VDPWR sky130_hd_ro41_nand_0.sky130_hd_inv_1_9.A 0.447f
C2252 sky130_hd_ro32_nand_0.sky130_hd_inv_1_30.Y sky130_hd_ro32_nand_0.sky130_hd_nand2_1_0.Y 0.0021f
C2253 a_28424_2159# sky130_hd_div_by_2_3.Qb 9.27e-22
C2254 clk a_23743_35715# 0.0204f
C2255 sky130_hd_div_by_2_2.Qb a_27903_3755# 7.65e-21
C2256 a_27999_3091# sky130_hd_div_by_2_4.Qb 0.00105f
C2257 sky130_hd_ro41_nand_0.sky130_hd_inv_1_8.A sky130_hd_ro41_nand_0.sky130_hd_inv_1_9.A 0.16f
C2258 sky130_hd_ro32_nand_0.sky130_hd_inv_1_4.Y ena 1.99e-19
C2259 sky130_hd_xor_block_3.sky130_hd_xor2_1_0.A sky130_hd_xor_block_2.sky130_hd_xor2_1_0.A 6.95e-20
C2260 sky130_hd_div_by_2_1.Qb sky130_hd_div_by_2_3.Q 1.67e-20
C2261 sky130_hd_xor_block_2.XORB sky130_hd_ro37_nand_0.sky130_hd_inv_1_34.Y 3.07e-19
C2262 sky130_hd_ro37_nand_0.sky130_hd_inv_1_9.Y sky130_hd_ro37_nand_0.sky130_hd_inv_1_1.A 5.04e-19
C2263 ua[1] a_28188_1565# 0.00631f
C2264 sky130_hd_ro33_nand_0.sky130_hd_inv_1_8.Y sky130_hd_xor_block_3.XORB 3.26e-19
C2265 sky130_hd_ro41_nand_0.sky130_hd_inv_1_10.A sky130_hd_ro41_nand_0.sky130_hd_inv_1_9.A 0.16f
C2266 VDPWR a_25118_30833# 0.291f
C2267 a_28742_1725# sky130_hd_div_by_2_1.Qb 0.147f
C2268 sky130_hd_ro32_nand_0.sky130_hd_inv_1_9.Y sky130_hd_ro32_nand_0.sky130_hd_inv_1_10.Y 0.16f
C2269 a_21429_33018# sky130_hd_xor_block_2.sky130_hd_xor2_1_0.A 0.00428f
C2270 sky130_hd_ro53_nand_0.sky130_hd_inv_1_34.Y sky130_hd_ro53_nand_0.sky130_hd_inv_1_35.Y 0.16f
C2271 a_28188_1565# a_28855_2213# 0.0084f
C2272 sky130_hd_div_by_2_3.Qb a_28195_2557# 0.00146f
C2273 sky130_hd_ro47_nand_0.sky130_hd_inv_1_37.Y sky130_hd_ro47_nand_0.sky130_hd_inv_1_36.Y 0.152f
C2274 VDPWR sky130_hd_ro37_nand_0.sky130_hd_inv_1_24.Y 0.436f
C2275 sky130_hd_xor_block_2.XORB sky130_hd_ro37_nand_0.sky130_hd_inv_1_20.Y 3.07e-19
C2276 a_28188_2653# a_28571_2435# 0.0027f
C2277 sky130_hd_ro41_nand_0.sky130_hd_inv_1_16.Y sky130_hd_ro41_nand_0.sky130_hd_inv_1_17.Y 0.16f
C2278 sky130_hd_inv_4_0.A sky130_hd_dfxtp_1_1.Q 6.18e-20
C2279 a_28188_3741# ua[0] 0.29f
C2280 sky130_hd_xor_block_2.XORB ui_in[4] 0.00778f
C2281 a_27903_2667# sky130_hd_div_by_2_3.Q 8.67e-19
C2282 sky130_hd_xor_block_3.XORB sky130_hd_ro37_nand_0.sky130_hd_inv_1_31.Y 9.5e-19
C2283 sky130_hd_xor_block_1.XORB sky130_hd_ro41_nand_0.sky130_hd_inv_1_19.Y 3.16e-19
C2284 a_28188_2653# sky130_hd_div_by_2_3.Q 0.292f
C2285 sky130_hd_ro32_nand_0.sky130_hd_inv_1_17.Y ua[0] 0.011f
C2286 ui_in[7] sky130_hd_ro53_nand_0.sky130_hd_inv_1_50.Y 5.69e-19
C2287 sky130_hd_ro53_nand_0.sky130_hd_inv_1_43.Y sky130_hd_ro53_nand_0.sky130_hd_inv_1_42.Y 0.152f
C2288 a_28395_2712# a_28324_1725# 3.2e-20
C2289 sky130_hd_ro53_nand_0.sky130_hd_inv_1_24.Y sky130_hd_ro53_nand_0.sky130_hd_inv_1_25.Y 0.16f
C2290 sky130_hd_ro37_nand_0.sky130_hd_inv_1_21.Y sky130_hd_ro41_nand_0.sky130_hd_inv_1_22.Y 6.22e-19
C2291 sky130_hd_inv_1_0.A a_22612_35563# 5.23e-19
C2292 a_22936_31990# a_23018_31990# 0.00294f
C2293 sky130_hd_ro32_nand_0.sky130_hd_inv_1_24.Y ena 1.99e-19
C2294 a_21179_33268# sky130_hd_xor_block_2.XOROUT 0.182f
C2295 sky130_hd_ro47_nand_0.sky130_hd_inv_1_25.Y sky130_hd_ro47_nand_0.sky130_hd_inv_1_27.Y 5.04e-19
C2296 a_27831_2257# a_27999_2003# 0.24f
C2297 clk a_22265_35537# 0.00245f
C2298 sky130_hd_div_by_2_4.Q a_28195_3645# 0.00229f
C2299 VDPWR sky130_hd_xor_block_3.sky130_hd_xor2_1_0.A 0.705f
C2300 a_27558_2979# sky130_hd_div_by_2_4.Qb 0.00105f
C2301 a_27558_2979# a_27536_3497# 4.8e-19
C2302 sky130_hd_xor_block_0.XORB sky130_hd_ro53_nand_0.sky130_hd_inv_1_28.Y 7.87e-19
C2303 VDPWR a_27536_1321# 0.21f
C2304 sky130_hd_xor_block_2.XORB sky130_hd_ro41_nand_0.sky130_hd_inv_1_27.Y 5.1e-19
C2305 a_21429_33018# VDPWR 2.45e-19
C2306 VDPWR a_28188_3741# 0.63f
C2307 a_27631_3850# sky130_hd_ro32_nand_0.sky130_hd_inv_1_1.Y 3.38e-20
C2308 sky130_hd_ro41_nand_0.sky130_hd_inv_1_2.A sky130_hd_ro41_nand_0.sky130_hd_inv_1_1.A 0.157f
C2309 a_28123_3889# sky130_hd_div_by_2_4.Qb 0.00107f
C2310 sky130_hd_ro32_nand_0.sky130_hd_inv_1_23.Y sky130_hd_ro32_nand_0.sky130_hd_inv_1_24.Y 0.16f
C2311 VDPWR sky130_hd_ro32_nand_0.sky130_hd_inv_1_17.Y 0.419f
C2312 sky130_hd_ro33_nand_0.sky130_hd_nand2_1_0.Y sky130_hd_ro33_nand_0.sky130_hd_inv_1_30.Y 0.0021f
C2313 VDPWR a_28256_2257# 0.187f
C2314 sky130_hd_ro41_nand_0.sky130_hd_inv_1_31.Y sky130_hd_ro41_nand_0.sky130_hd_inv_1_30.Y 0.152f
C2315 sky130_hd_ro47_nand_0.sky130_hd_nand2_1_0.Y a_4631_27642# 0.00964f
C2316 sky130_hd_ro32_nand_0.sky130_hd_inv_1_21.Y ena 1.99e-19
C2317 sky130_hd_div_by_2_4.Q a_27392_1891# 6.11e-20
C2318 sky130_hd_ro33_nand_0.sky130_hd_inv_1_13.Y sky130_hd_ro33_nand_0.sky130_hd_inv_1_14.Y 0.16f
C2319 a_27631_2762# a_27536_2409# 0.108f
C2320 sky130_hd_div_by_2_3.Q a_27392_2979# 0.00667f
C2321 VDPWR sky130_hd_ro33_nand_0.sky130_hd_inv_1_15.Y 0.442f
C2322 sky130_hd_ro32_nand_0.sky130_hd_inv_1_24.Y sky130_hd_ro32_nand_0.sky130_hd_inv_1_22.Y 5.04e-19
C2323 VDPWR sky130_hd_ro53_nand_0.sky130_hd_inv_1_50.Y 0.422f
C2324 sky130_hd_ro32_nand_0.sky130_hd_inv_1_23.Y sky130_hd_ro32_nand_0.sky130_hd_inv_1_21.Y 5.04e-19
C2325 clk a_24123_35537# 0.285f
C2326 sky130_hd_xor_block_2.sky130_hd_inv_1_3.A sky130_hd_xor_block_2.sky130_hd_inv_1_1.Y 0.0274f
C2327 sky130_hd_ro32_nand_0.sky130_hd_inv_1_7.Y sky130_hd_ro32_nand_0.sky130_hd_inv_1_5.Y 5.04e-19
C2328 sky130_hd_ro33_nand_0.sky130_hd_inv_1_9.Y sky130_hd_ro33_nand_0.sky130_hd_inv_1_7.Y 5.04e-19
C2329 sky130_hd_ro41_nand_0.sky130_hd_inv_1_28.Y sky130_hd_ro41_nand_0.sky130_hd_inv_1_27.Y 0.16f
C2330 VDPWR a_27999_2003# 0.184f
C2331 a_21678_35715# clk 0.00116f
C2332 sky130_hd_ro41_nand_0.sky130_hd_inv_1_29.A VDPWR 0.443f
C2333 sky130_hd_xor_block_2.XORB sky130_hd_xor_block_3.XORB 0.0635f
C2334 sky130_hd_ro47_nand_0.sky130_hd_inv_1_5.Y sky130_hd_ro47_nand_0.sky130_hd_inv_1_3.Y 5.04e-19
C2335 sky130_hd_div_by_2_0.Qb a_28382_1891# 9.73e-19
C2336 sky130_hd_xor_block_2.XOROUT sky130_hd_xor_block_1.sky130_hd_xor2_1_0.B 0.00761f
C2337 sky130_hd_ro53_nand_0.sky130_hd_inv_1_36.Y sky130_hd_xor_block_0.XORB 7.87e-19
C2338 a_27831_2257# sky130_hd_div_by_2_2.Qb 0.00261f
C2339 sky130_hd_ro41_nand_0.sky130_hd_inv_1_26.Y sky130_hd_ro41_nand_0.sky130_hd_inv_1_25.Y 0.16f
C2340 sky130_hd_ro47_nand_0.sky130_hd_inv_1_34.Y sky130_hd_ro47_nand_0.sky130_hd_inv_1_32.Y 5.04e-19
C2341 sky130_hd_ro32_nand_0.sky130_hd_inv_1_21.Y sky130_hd_ro32_nand_0.sky130_hd_inv_1_22.Y 0.16f
C2342 sky130_hd_ro33_nand_0.sky130_hd_inv_1_2.Y sky130_hd_ro33_nand_0.sky130_hd_inv_1_1.Y 0.16f
C2343 a_28324_3901# a_28188_3741# 0.141f
C2344 a_28424_2159# a_28382_1891# 7.8e-20
C2345 sky130_hd_div_by_2_3.Qb a_27631_2762# 0.00959f
C2346 ua[0] sky130_hd_div_by_2_2.Qb 2.3e-19
C2347 sky130_hd_ro41_nand_0.sky130_hd_inv_1_24.Y VDPWR 0.438f
C2348 sky130_hd_ro33_nand_0.sky130_hd_inv_1_7.Y sky130_hd_xor_block_3.XORB 3.26e-19
C2349 a_28742_2813# a_28324_2813# 3.39e-19
C2350 sky130_hd_div_by_2_3.Qb a_27903_3755# 0.00449f
C2351 a_22441_35929# a_22058_35537# 0.0027f
C2352 sky130_hd_ro37_nand_0.sky130_hd_inv_1_4.A sky130_hd_xor_block_3.XORB 0.00233f
C2353 sky130_hd_ro47_nand_0.sky130_hd_inv_1_38.Y sky130_hd_ro47_nand_0.sky130_hd_inv_1_40.Y 5.04e-19
C2354 sky130_hd_xor_block_3.sky130_hd_inv_1_1.Y sky130_hd_xor_block_3.sky130_hd_inv_1_3.A 0.0274f
C2355 sky130_hd_xor_block_3.XORB sky130_hd_ro37_nand_0.sky130_hd_inv_1_27.Y 4.75e-19
C2356 sky130_hd_xor_block_2.XORB sky130_hd_ro37_nand_0.sky130_hd_inv_1_26.Y 3.07e-19
C2357 sky130_hd_xor_block_1.XORB sky130_hd_xor_block_0.XORB 0.165f
C2358 VDPWR sky130_hd_ro33_nand_0.sky130_hd_inv_1_17.Y 0.465f
C2359 VDPWR sky130_hd_ro47_nand_0.sky130_hd_inv_1_37.Y 0.439f
C2360 VDPWR sky130_hd_ro41_nand_0.sky130_hd_inv_1_22.Y 0.445f
C2361 a_27392_1891# sky130_hd_div_by_2_2.Q 0.309f
C2362 VDPWR sky130_hd_div_by_2_2.Qb 0.403f
C2363 uo_out[0] ui_in[6] 0.184f
C2364 sky130_hd_ro53_nand_0.sky130_hd_inv_1_10.Y sky130_hd_ro53_nand_0.sky130_hd_inv_1_11.Y 0.16f
C2365 sky130_hd_ro37_nand_0.sky130_hd_inv_1_26.Y sky130_hd_ro37_nand_0.sky130_hd_inv_1_27.Y 0.152f
C2366 sky130_hd_ro47_nand_0.sky130_hd_inv_1_25.Y sky130_hd_ro47_nand_0.sky130_hd_inv_1_23.Y 5.04e-19
C2367 a_27746_2979# a_27999_3091# 3.39e-19
C2368 sky130_hd_xor_block_1.sky130_hd_xor2_1_0.A sky130_hd_xor_block_1.sky130_hd_inv_1_1.Y 0.149f
C2369 sky130_hd_ro47_nand_0.sky130_hd_inv_1_43.Y sky130_hd_ro47_nand_0.sky130_hd_nand2_1_0.Y 6.18e-19
C2370 sky130_hd_ro41_nand_0.sky130_hd_inv_1_28.Y sky130_hd_ro37_nand_0.sky130_hd_inv_1_26.Y 6.22e-19
C2371 a_24479_35563# clk 6.36e-19
C2372 VDPWR sky130_hd_ro47_nand_0.sky130_hd_inv_1_1.Y 0.442f
C2373 sky130_hd_div_by_2_0.Qb a_28188_1565# 0.00271f
C2374 VDPWR sky130_hd_ro53_nand_0.sky130_hd_inv_1_3.Y 0.457f
C2375 a_28424_2159# a_28188_1565# 0.0103f
C2376 a_19286_4740# ua[0] 2.51e-20
C2377 sky130_hd_xor_block_1.sky130_hd_xor2_1_0.A sky130_hd_xor_block_1.sky130_hd_inv_1_3.A 0.00398f
C2378 sky130_hd_ro32_nand_0.sky130_hd_inv_1_2.Y ena 1.99e-19
C2379 sky130_hd_ro37_nand_0.sky130_hd_inv_1_23.Y sky130_hd_xor_block_3.XORB 4.75e-19
C2380 sky130_hd_ro33_nand_0.sky130_hd_inv_1_10.Y sky130_hd_ro33_nand_0.sky130_hd_inv_1_12.Y 5.04e-19
C2381 sky130_hd_ro33_nand_0.sky130_hd_inv_1_19.Y sky130_hd_ro33_nand_0.sky130_hd_inv_1_20.Y 0.16f
C2382 a_21993_35563# sky130_hd_dfxtp_1_1.Q 1.29e-19
C2383 sky130_hd_ro41_nand_0.sky130_hd_inv_1_5.A sky130_hd_ro41_nand_0.sky130_hd_inv_1_6.A 0.16f
C2384 a_27903_1579# a_27999_2003# 0.00273f
C2385 a_24058_35563# sky130_hd_xor_block_0.XOROUT 1.27e-19
C2386 VDPWR sky130_hd_ro37_nand_0.sky130_hd_inv_1_25.Y 0.435f
C2387 a_28188_1565# a_28195_2557# 6.29e-19
C2388 VDPWR a_23186_31990# 0.291f
C2389 a_23839_35537# a_22058_35537# 1.57e-21
C2390 sky130_hd_ro33_nand_0.sky130_hd_inv_1_5.Y sky130_hd_ro33_nand_0.sky130_hd_inv_1_4.Y 0.16f
C2391 sky130_hd_ro53_nand_0.sky130_hd_inv_1_34.Y sky130_hd_ro53_nand_0.sky130_hd_inv_1_32.Y 2.69e-19
C2392 sky130_hd_xor_block_0.XOROUT sky130_hd_xor_block_0.sky130_hd_inv_1_3.A 8.71e-19
C2393 sky130_hd_xor_block_3.XORA sky130_hd_ro37_nand_0.sky130_hd_inv_1_32.Y 1.87e-19
C2394 sky130_hd_ro53_nand_0.sky130_hd_inv_1_43.Y VDPWR 0.445f
C2395 ua[0] ena 0.28f
C2396 sky130_hd_div_by_2_4.Q a_27631_3850# 0.16f
C2397 a_28256_3345# a_28382_2979# 0.00617f
C2398 a_28324_3901# sky130_hd_div_by_2_2.Qb 1.51e-21
C2399 a_22414_35563# sky130_hd_dfxtp_1_1.Q 6.94e-19
C2400 sky130_hd_ro41_nand_0.sky130_hd_inv_1_39.Y sky130_hd_ro41_nand_0.sky130_hd_inv_1_38.Y 0.16f
C2401 sky130_hd_ro37_nand_0.sky130_hd_inv_1_1.A sky130_hd_ro37_nand_0.sky130_hd_inv_1_3.A 5.04e-19
C2402 VDPWR sky130_hd_ro41_nand_0.sky130_hd_inv_1_21.Y 0.484f
C2403 sky130_hd_ro47_nand_0.sky130_hd_inv_1_4.Y sky130_hd_ro47_nand_0.sky130_hd_inv_1_3.Y 0.16f
C2404 sky130_hd_div_by_2_3.Q a_27957_2979# 9.74e-20
C2405 sky130_hd_ro47_nand_0.sky130_hd_inv_1_45.Y ui_in[6] 9.39e-20
C2406 ena sky130_hd_ro32_nand_0.sky130_hd_inv_1_27.Y 2.01e-19
C2407 a_19286_4740# VDPWR 2.17e-19
C2408 VDPWR sky130_hd_ro41_nand_0.sky130_hd_inv_1_38.Y 0.419f
C2409 sky130_hd_ro53_nand_0.sky130_hd_inv_1_51.Y sky130_hd_ro53_nand_0.sky130_hd_inv_1_50.Y 0.16f
C2410 a_27746_2979# a_27558_2979# 0.0982f
C2411 sky130_hd_ro32_nand_0.sky130_hd_inv_1_23.Y ua[0] 0.0108f
C2412 sky130_hd_ro41_nand_0.sky130_hd_inv_1_29.A sky130_hd_ro41_nand_0.sky130_hd_inv_1_29.Y 0.16f
C2413 sky130_hd_div_by_2_0.Qb a_27926_2257# 6.88e-19
C2414 sky130_hd_xor_block_3.XORB sky130_hd_ro33_nand_0.sky130_hd_inv_1_2.Y 3.26e-19
C2415 sky130_hd_xor_block_0.XORB sky130_hd_ro53_nand_0.sky130_hd_inv_1_49.Y 0.00551f
C2416 sky130_hd_div_by_2_1.Qb a_28571_1347# 7.07e-19
C2417 sky130_hd_ro47_nand_0.sky130_hd_inv_1_35.Y sky130_hd_ro47_nand_0.sky130_hd_inv_1_35.A 0.16f
C2418 sky130_hd_ro47_nand_0.sky130_hd_nand2_1_0.Y sky130_hd_ro47_nand_0.sky130_hd_inv_1_42.Y 3.32e-19
C2419 sky130_hd_ro47_nand_0.sky130_hd_inv_1_2.Y VDPWR 0.449f
C2420 sky130_hd_ro33_nand_0.sky130_hd_inv_1_25.Y sky130_hd_ro33_nand_0.sky130_hd_inv_1_27.Y 5.04e-19
C2421 sky130_hd_ro33_nand_0.sky130_hd_inv_1_30.Y sky130_hd_ro33_nand_0.sky130_hd_inv_1_28.Y 5.04e-19
C2422 ui_in[5] sky130_hd_xor_block_1.XORB 0.00526f
C2423 sky130_hd_ro53_nand_0.sky130_hd_inv_1_40.Y sky130_hd_ro53_nand_0.sky130_hd_inv_1_41.Y 0.16f
C2424 VDPWR a_28395_2712# 0.249f
C2425 ua[0] sky130_hd_ro32_nand_0.sky130_hd_inv_1_22.Y 0.011f
C2426 sky130_hd_ro37_nand_0.sky130_hd_inv_1_25.A sky130_hd_ro37_nand_0.sky130_hd_inv_1_24.Y 5.04e-19
C2427 VDPWR ena 0.319f
C2428 sky130_hd_ro53_nand_0.sky130_hd_inv_1_27.Y sky130_hd_ro53_nand_0.sky130_hd_inv_1_26.Y 0.16f
C2429 sky130_hd_ro33_nand_0.sky130_hd_inv_1_20.Y sky130_hd_ro37_nand_0.sky130_hd_inv_1_20.Y 2.28e-19
C2430 sky130_hd_div_by_2_3.Qb ua[0] 0.00159f
C2431 sky130_hd_ro53_nand_0.sky130_hd_inv_1_19.A sky130_hd_xor_block_0.XORB 7.87e-19
C2432 VDPWR a_27536_2409# 0.211f
C2433 sky130_hd_xor_block_2.XORB sky130_hd_ro41_nand_0.sky130_hd_inv_1_37.Y 0.00464f
C2434 uo_out[0] uio_in[7] 0.032f
C2435 sky130_hd_ro53_nand_0.sky130_hd_inv_1_47.Y sky130_hd_ro53_nand_0.sky130_hd_inv_1_46.Y 0.16f
C2436 sky130_hd_ro37_nand_0.sky130_hd_inv_1_2.A sky130_hd_xor_block_2.XORB 3.07e-19
C2437 sky130_hd_ro33_nand_0.sky130_hd_inv_1_16.Y sky130_hd_ro37_nand_0.sky130_hd_inv_1_16.Y 6.23e-19
C2438 sky130_hd_ro33_nand_0.sky130_hd_inv_1_8.Y sky130_hd_ro37_nand_0.sky130_hd_inv_1_8.Y 2.28e-19
C2439 sky130_hd_ro32_nand_0.sky130_hd_inv_1_23.Y VDPWR 0.429f
C2440 a_28188_1565# a_28324_1725# 0.141f
C2441 sky130_hd_div_by_2_2.Q a_28324_2813# 0.00112f
C2442 sky130_hd_ro37_nand_0.sky130_hd_inv_1_18.Y sky130_hd_ro37_nand_0.sky130_hd_inv_1_16.Y 2.69e-19
C2443 sky130_hd_ro32_nand_0.sky130_hd_inv_1_18.Y sky130_hd_ro32_nand_0.sky130_hd_inv_1_16.Y 5.04e-19
C2444 VDPWR sky130_hd_ro53_nand_0.sky130_hd_inv_1_11.Y 0.435f
C2445 sky130_hd_ro41_nand_0.sky130_hd_inv_1_36.Y sky130_hd_ro41_nand_0.sky130_hd_inv_1_38.Y 5.04e-19
C2446 a_24868_30833# sky130_hd_xor_block_0.sky130_hd_xor2_1_0.A 0.0956f
C2447 uio_in[3] uio_in[2] 0.031f
C2448 a_19527_33932# sky130_hd_xor_block_3.sky130_hd_xor2_1_0.A 4.43e-19
C2449 sky130_hd_ro53_nand_0.sky130_hd_inv_1_37.Y sky130_hd_ro53_nand_0.sky130_hd_inv_1_39.Y 5.04e-19
C2450 a_27631_3850# sky130_hd_div_by_2_2.Q 4.17e-20
C2451 sky130_hd_ro41_nand_0.sky130_hd_nand2_1_0.Y sky130_hd_xor_block_1.XORB 0.00204f
C2452 VDPWR sky130_hd_ro32_nand_0.sky130_hd_inv_1_22.Y 0.419f
C2453 ena sky130_hd_ro32_nand_0.sky130_hd_inv_1_14.Y 1.99e-19
C2454 VDPWR sky130_hd_div_by_2_3.Qb 0.405f
C2455 ua[2] uo_out[7] 0.147f
C2456 ua[3] uo_out[7] 0.147f
C2457 ua[4] uo_out[7] 0.147f
C2458 ua[5] uo_out[7] 0.147f
C2459 ua[6] uo_out[7] 0.147f
C2460 ua[7] uo_out[7] 0.147f
C2461 rst_n uo_out[7] 0.0362f
C2462 ui_in[0] uo_out[7] 0.0429f
C2463 ui_in[1] uo_out[7] 0.0429f
C2464 ui_in[2] uo_out[7] 0.0417f
C2465 uio_in[0] uo_out[7] 0.0417f
C2466 uio_in[1] uo_out[7] 0.0429f
C2467 uio_in[2] uo_out[7] 0.0429f
C2468 uio_in[3] uo_out[7] 0.0429f
C2469 uio_in[4] uo_out[7] 0.0429f
C2470 uio_in[5] uo_out[7] 0.0414f
C2471 uio_in[6] uo_out[7] 0.042f
C2472 uio_in[7] uo_out[7] 0.042f
C2473 ua[1] uo_out[7] 1.54f
C2474 ua[0] uo_out[7] 7.36f
C2475 ena uo_out[7] 21.1f
C2476 ui_in[7] uo_out[7] 15.3f
C2477 ui_in[6] uo_out[7] 10.1f
C2478 ui_in[5] uo_out[7] 8.61f
C2479 ui_in[4] uo_out[7] 8.11f
C2480 ui_in[3] uo_out[7] 9.74f
C2481 clk uo_out[7] 6.59f
C2482 uo_out[0] uo_out[7] 6.55f
C2483 VDPWR uo_out[7] 0.289p
C2484 a_28146_1347# uo_out[7] 4.07e-19
C2485 a_28742_1725# uo_out[7] 0.0647f
C2486 a_28544_1713# uo_out[7] 0.00748f
C2487 a_28123_1713# uo_out[7] 0.00452f
C2488 sky130_hd_div_by_2_1.Qb uo_out[7] 0.908f
C2489 a_28324_1725# uo_out[7] 0.264f
C2490 a_28395_1624# uo_out[7] 0.217f
C2491 a_28195_1469# uo_out[7] 0.442f
C2492 a_28188_1565# uo_out[7] 0.552f
C2493 a_27903_1579# uo_out[7] 0.284f
C2494 a_27631_1674# uo_out[7] 0.553f
C2495 a_27536_1321# uo_out[7] 0.217f
C2496 a_28382_1891# uo_out[7] 0.00448f
C2497 sky130_hd_div_by_2_1.CLK uo_out[7] 0.67f
C2498 a_27957_1891# uo_out[7] 0.00759f
C2499 a_28340_2257# uo_out[7] 4.07e-19
C2500 a_27746_1891# uo_out[7] 0.0649f
C2501 a_28855_2213# uo_out[7] 0.21f
C2502 a_28256_2257# uo_out[7] 0.275f
C2503 a_28424_2159# uo_out[7] 0.526f
C2504 a_27831_2257# uo_out[7] 0.209f
C2505 a_27999_2003# uo_out[7] 0.258f
C2506 a_27558_1891# uo_out[7] 0.426f
C2507 sky130_hd_div_by_2_0.Qb uo_out[7] 0.797f
C2508 a_27392_1891# uo_out[7] 0.533f
C2509 a_28146_2435# uo_out[7] 4.07e-19
C2510 a_28742_2813# uo_out[7] 0.0647f
C2511 a_28544_2801# uo_out[7] 0.00748f
C2512 a_28123_2801# uo_out[7] 0.00452f
C2513 sky130_hd_div_by_2_2.Q uo_out[7] 0.524f
C2514 sky130_hd_div_by_2_2.Qb uo_out[7] 0.774f
C2515 a_28324_2813# uo_out[7] 0.257f
C2516 a_28395_2712# uo_out[7] 0.208f
C2517 a_28195_2557# uo_out[7] 0.426f
C2518 a_28188_2653# uo_out[7] 0.529f
C2519 a_27903_2667# uo_out[7] 0.274f
C2520 a_27631_2762# uo_out[7] 0.525f
C2521 a_27536_2409# uo_out[7] 0.21f
C2522 a_28382_2979# uo_out[7] 0.00447f
C2523 sky130_hd_div_by_2_3.Q uo_out[7] 0.615f
C2524 a_27957_2979# uo_out[7] 0.00758f
C2525 a_28340_3345# uo_out[7] 4.07e-19
C2526 a_27746_2979# uo_out[7] 0.0649f
C2527 a_28855_3301# uo_out[7] 0.209f
C2528 a_28256_3345# uo_out[7] 0.275f
C2529 a_28424_3247# uo_out[7] 0.526f
C2530 a_27831_3345# uo_out[7] 0.209f
C2531 a_27999_3091# uo_out[7] 0.257f
C2532 a_27558_2979# uo_out[7] 0.427f
C2533 sky130_hd_div_by_2_3.Qb uo_out[7] 0.771f
C2534 a_27392_2979# uo_out[7] 0.532f
C2535 a_28146_3523# uo_out[7] 4.07e-19
C2536 a_28742_3901# uo_out[7] 0.0647f
C2537 a_28544_3889# uo_out[7] 0.00748f
C2538 a_28123_3889# uo_out[7] 0.00452f
C2539 sky130_hd_div_by_2_4.Q uo_out[7] 0.529f
C2540 sky130_hd_div_by_2_4.Qb uo_out[7] 1.43f
C2541 a_28324_3901# uo_out[7] 0.26f
C2542 a_28395_3800# uo_out[7] 0.213f
C2543 a_28195_3645# uo_out[7] 0.435f
C2544 a_28188_3741# uo_out[7] 0.546f
C2545 a_27903_3755# uo_out[7] 0.281f
C2546 a_27631_3850# uo_out[7] 0.539f
C2547 a_27536_3497# uo_out[7] 0.217f
C2548 a_19286_4740# uo_out[7] 0.00202f
C2549 sky130_hd_ro32_nand_0.sky130_hd_inv_1_1.Y uo_out[7] 0.522f
C2550 sky130_hd_ro32_nand_0.sky130_hd_inv_1_2.Y uo_out[7] 0.505f
C2551 sky130_hd_ro32_nand_0.sky130_hd_inv_1_3.Y uo_out[7] 0.504f
C2552 sky130_hd_ro32_nand_0.sky130_hd_inv_1_4.Y uo_out[7] 0.506f
C2553 sky130_hd_ro32_nand_0.sky130_hd_inv_1_5.Y uo_out[7] 0.507f
C2554 sky130_hd_ro32_nand_0.sky130_hd_inv_1_6.Y uo_out[7] 0.507f
C2555 sky130_hd_ro32_nand_0.sky130_hd_inv_1_7.Y uo_out[7] 0.508f
C2556 sky130_hd_ro32_nand_0.sky130_hd_inv_1_8.Y uo_out[7] 0.508f
C2557 sky130_hd_ro32_nand_0.sky130_hd_inv_1_9.Y uo_out[7] 0.51f
C2558 sky130_hd_ro32_nand_0.sky130_hd_inv_1_10.Y uo_out[7] 0.517f
C2559 sky130_hd_ro32_nand_0.sky130_hd_inv_1_11.Y uo_out[7] 0.518f
C2560 sky130_hd_ro32_nand_0.sky130_hd_inv_1_12.Y uo_out[7] 0.512f
C2561 sky130_hd_ro32_nand_0.sky130_hd_inv_1_13.Y uo_out[7] 0.512f
C2562 sky130_hd_ro32_nand_0.sky130_hd_inv_1_14.Y uo_out[7] 0.501f
C2563 sky130_hd_ro32_nand_0.sky130_hd_inv_1_15.Y uo_out[7] 0.512f
C2564 sky130_hd_ro32_nand_0.sky130_hd_inv_1_16.Y uo_out[7] 0.512f
C2565 sky130_hd_ro32_nand_0.sky130_hd_inv_1_17.Y uo_out[7] 0.512f
C2566 sky130_hd_ro32_nand_0.sky130_hd_inv_1_18.Y uo_out[7] 0.512f
C2567 sky130_hd_ro32_nand_0.sky130_hd_inv_1_19.Y uo_out[7] 0.512f
C2568 sky130_hd_ro32_nand_0.sky130_hd_inv_1_20.Y uo_out[7] 0.512f
C2569 sky130_hd_ro32_nand_0.sky130_hd_inv_1_21.Y uo_out[7] 0.512f
C2570 sky130_hd_ro32_nand_0.sky130_hd_inv_1_22.Y uo_out[7] 0.512f
C2571 sky130_hd_ro32_nand_0.sky130_hd_inv_1_23.Y uo_out[7] 0.501f
C2572 sky130_hd_ro32_nand_0.sky130_hd_inv_1_24.Y uo_out[7] 0.512f
C2573 sky130_hd_ro32_nand_0.sky130_hd_inv_1_25.Y uo_out[7] 0.512f
C2574 sky130_hd_ro32_nand_0.sky130_hd_inv_1_26.Y uo_out[7] 0.512f
C2575 sky130_hd_ro32_nand_0.sky130_hd_inv_1_27.Y uo_out[7] 0.512f
C2576 sky130_hd_ro32_nand_0.sky130_hd_inv_1_28.Y uo_out[7] 0.512f
C2577 sky130_hd_ro32_nand_0.sky130_hd_inv_1_29.Y uo_out[7] 0.512f
C2578 sky130_hd_ro32_nand_0.sky130_hd_inv_1_30.Y uo_out[7] 0.512f
C2579 sky130_hd_ro32_nand_0.sky130_hd_inv_1_31.Y uo_out[7] 0.513f
C2580 sky130_hd_ro32_nand_0.sky130_hd_nand2_1_0.Y uo_out[7] 0.742f
C2581 a_2975_25393# uo_out[7] 0.00194f
C2582 sky130_hd_ro53_nand_0.sky130_hd_inv_1_1.Y uo_out[7] 0.54f
C2583 sky130_hd_ro53_nand_0.sky130_hd_inv_1_2.Y uo_out[7] 0.527f
C2584 sky130_hd_ro53_nand_0.sky130_hd_inv_1_3.Y uo_out[7] 0.527f
C2585 sky130_hd_ro53_nand_0.sky130_hd_inv_1_4.Y uo_out[7] 0.528f
C2586 sky130_hd_ro53_nand_0.sky130_hd_inv_1_5.Y uo_out[7] 0.574f
C2587 sky130_hd_ro53_nand_0.sky130_hd_inv_1_6.Y uo_out[7] 0.535f
C2588 sky130_hd_ro53_nand_0.sky130_hd_inv_1_7.Y uo_out[7] 0.531f
C2589 sky130_hd_ro53_nand_0.sky130_hd_inv_1_8.Y uo_out[7] 0.533f
C2590 sky130_hd_ro53_nand_0.sky130_hd_inv_1_9.Y uo_out[7] 0.534f
C2591 sky130_hd_ro53_nand_0.sky130_hd_inv_1_10.Y uo_out[7] 0.542f
C2592 sky130_hd_ro53_nand_0.sky130_hd_inv_1_11.Y uo_out[7] 0.571f
C2593 sky130_hd_ro53_nand_0.sky130_hd_inv_1_22.Y uo_out[7] 0.556f
C2594 sky130_hd_ro53_nand_0.sky130_hd_inv_1_22.A uo_out[7] 0.535f
C2595 sky130_hd_ro53_nand_0.sky130_hd_inv_1_21.A uo_out[7] 0.533f
C2596 sky130_hd_ro53_nand_0.sky130_hd_inv_1_20.A uo_out[7] 0.531f
C2597 sky130_hd_ro53_nand_0.sky130_hd_inv_1_19.A uo_out[7] 0.53f
C2598 sky130_hd_ro53_nand_0.sky130_hd_inv_1_18.A uo_out[7] 0.529f
C2599 sky130_hd_ro53_nand_0.sky130_hd_inv_1_17.A uo_out[7] 0.528f
C2600 sky130_hd_ro53_nand_0.sky130_hd_inv_1_16.A uo_out[7] 0.529f
C2601 sky130_hd_ro53_nand_0.sky130_hd_inv_1_15.A uo_out[7] 0.574f
C2602 sky130_hd_ro53_nand_0.sky130_hd_inv_1_14.A uo_out[7] 0.537f
C2603 sky130_hd_ro53_nand_0.sky130_hd_inv_1_13.A uo_out[7] 0.578f
C2604 sky130_hd_ro53_nand_0.sky130_hd_inv_1_24.Y uo_out[7] 0.54f
C2605 sky130_hd_ro53_nand_0.sky130_hd_inv_1_25.Y uo_out[7] 0.55f
C2606 sky130_hd_ro53_nand_0.sky130_hd_inv_1_26.Y uo_out[7] 0.575f
C2607 sky130_hd_ro53_nand_0.sky130_hd_inv_1_27.Y uo_out[7] 0.551f
C2608 sky130_hd_ro53_nand_0.sky130_hd_inv_1_28.Y uo_out[7] 0.535f
C2609 sky130_hd_ro53_nand_0.sky130_hd_inv_1_29.Y uo_out[7] 0.533f
C2610 sky130_hd_ro53_nand_0.sky130_hd_inv_1_30.Y uo_out[7] 0.531f
C2611 sky130_hd_ro53_nand_0.sky130_hd_inv_1_31.Y uo_out[7] 0.53f
C2612 sky130_hd_ro53_nand_0.sky130_hd_inv_1_32.Y uo_out[7] 0.53f
C2613 sky130_hd_ro53_nand_0.sky130_hd_inv_1_33.Y uo_out[7] 0.572f
C2614 sky130_hd_ro53_nand_0.sky130_hd_inv_1_34.Y uo_out[7] 0.533f
C2615 sky130_hd_ro53_nand_0.sky130_hd_inv_1_35.Y uo_out[7] 0.53f
C2616 sky130_hd_ro53_nand_0.sky130_hd_inv_1_36.Y uo_out[7] 0.531f
C2617 sky130_hd_ro53_nand_0.sky130_hd_inv_1_37.Y uo_out[7] 0.533f
C2618 sky130_hd_ro53_nand_0.sky130_hd_inv_1_38.Y uo_out[7] 0.534f
C2619 sky130_hd_ro53_nand_0.sky130_hd_inv_1_39.Y uo_out[7] 0.542f
C2620 sky130_hd_ro53_nand_0.sky130_hd_inv_1_40.Y uo_out[7] 0.571f
C2621 sky130_hd_ro53_nand_0.sky130_hd_inv_1_41.Y uo_out[7] 0.555f
C2622 sky130_hd_ro53_nand_0.sky130_hd_inv_1_41.A uo_out[7] 0.536f
C2623 sky130_hd_ro53_nand_0.sky130_hd_inv_1_42.Y uo_out[7] 0.577f
C2624 sky130_hd_ro53_nand_0.sky130_hd_inv_1_43.Y uo_out[7] 0.536f
C2625 sky130_hd_ro53_nand_0.sky130_hd_inv_1_44.Y uo_out[7] 0.53f
C2626 sky130_hd_ro53_nand_0.sky130_hd_inv_1_45.Y uo_out[7] 0.528f
C2627 sky130_hd_ro53_nand_0.sky130_hd_inv_1_46.Y uo_out[7] 0.527f
C2628 sky130_hd_ro53_nand_0.sky130_hd_inv_1_47.Y uo_out[7] 0.527f
C2629 sky130_hd_ro53_nand_0.sky130_hd_inv_1_48.Y uo_out[7] 0.52f
C2630 sky130_hd_ro53_nand_0.sky130_hd_inv_1_49.Y uo_out[7] 0.509f
C2631 sky130_hd_ro53_nand_0.sky130_hd_inv_1_50.Y uo_out[7] 0.507f
C2632 sky130_hd_ro53_nand_0.sky130_hd_inv_1_51.Y uo_out[7] 0.508f
C2633 sky130_hd_ro53_nand_0.sky130_hd_nand2_1_0.Y uo_out[7] 0.734f
C2634 a_4631_27642# uo_out[7] 0.00199f
C2635 sky130_hd_ro47_nand_0.sky130_hd_inv_1_1.Y uo_out[7] 0.546f
C2636 sky130_hd_ro47_nand_0.sky130_hd_inv_1_2.Y uo_out[7] 0.531f
C2637 sky130_hd_ro47_nand_0.sky130_hd_inv_1_3.Y uo_out[7] 0.529f
C2638 sky130_hd_ro47_nand_0.sky130_hd_inv_1_4.Y uo_out[7] 0.527f
C2639 sky130_hd_ro47_nand_0.sky130_hd_inv_1_5.Y uo_out[7] 0.531f
C2640 sky130_hd_ro47_nand_0.sky130_hd_inv_1_16.Y uo_out[7] 0.534f
C2641 sky130_hd_ro47_nand_0.sky130_hd_inv_1_16.A uo_out[7] 0.535f
C2642 sky130_hd_ro47_nand_0.sky130_hd_inv_1_15.A uo_out[7] 0.537f
C2643 sky130_hd_ro47_nand_0.sky130_hd_inv_1_14.A uo_out[7] 0.539f
C2644 sky130_hd_ro47_nand_0.sky130_hd_inv_1_13.A uo_out[7] 0.545f
C2645 sky130_hd_ro47_nand_0.sky130_hd_inv_1_12.A uo_out[7] 0.573f
C2646 sky130_hd_ro47_nand_0.sky130_hd_inv_1_11.A uo_out[7] 0.559f
C2647 sky130_hd_ro47_nand_0.sky130_hd_inv_1_10.A uo_out[7] 0.54f
C2648 sky130_hd_ro47_nand_0.sky130_hd_inv_1_9.A uo_out[7] 0.582f
C2649 sky130_hd_ro47_nand_0.sky130_hd_inv_1_8.A uo_out[7] 0.541f
C2650 sky130_hd_ro47_nand_0.sky130_hd_inv_1_7.A uo_out[7] 0.579f
C2651 sky130_hd_ro47_nand_0.sky130_hd_inv_1_18.Y uo_out[7] 0.535f
C2652 sky130_hd_ro47_nand_0.sky130_hd_inv_1_19.Y uo_out[7] 0.527f
C2653 sky130_hd_ro47_nand_0.sky130_hd_inv_1_20.Y uo_out[7] 0.532f
C2654 sky130_hd_ro47_nand_0.sky130_hd_inv_1_21.Y uo_out[7] 0.534f
C2655 sky130_hd_ro47_nand_0.sky130_hd_inv_1_22.Y uo_out[7] 0.536f
C2656 sky130_hd_ro47_nand_0.sky130_hd_inv_1_23.Y uo_out[7] 0.537f
C2657 sky130_hd_ro47_nand_0.sky130_hd_inv_1_24.Y uo_out[7] 0.539f
C2658 sky130_hd_ro47_nand_0.sky130_hd_inv_1_25.Y uo_out[7] 0.553f
C2659 sky130_hd_ro47_nand_0.sky130_hd_inv_1_26.Y uo_out[7] 0.577f
C2660 sky130_hd_ro47_nand_0.sky130_hd_inv_1_27.Y uo_out[7] 0.6f
C2661 sky130_hd_ro47_nand_0.sky130_hd_inv_1_28.Y uo_out[7] 0.543f
C2662 sky130_hd_ro47_nand_0.sky130_hd_inv_1_29.Y uo_out[7] 0.537f
C2663 sky130_hd_ro47_nand_0.sky130_hd_inv_1_30.Y uo_out[7] 0.535f
C2664 sky130_hd_ro47_nand_0.sky130_hd_inv_1_31.Y uo_out[7] 0.534f
C2665 sky130_hd_ro47_nand_0.sky130_hd_inv_1_32.Y uo_out[7] 0.531f
C2666 sky130_hd_ro47_nand_0.sky130_hd_inv_1_33.Y uo_out[7] 0.527f
C2667 sky130_hd_ro47_nand_0.sky130_hd_inv_1_34.Y uo_out[7] 0.531f
C2668 sky130_hd_ro47_nand_0.sky130_hd_inv_1_35.Y uo_out[7] 0.534f
C2669 sky130_hd_ro47_nand_0.sky130_hd_inv_1_35.A uo_out[7] 0.536f
C2670 sky130_hd_ro47_nand_0.sky130_hd_inv_1_36.Y uo_out[7] 0.582f
C2671 sky130_hd_ro47_nand_0.sky130_hd_inv_1_37.Y uo_out[7] 0.545f
C2672 sky130_hd_ro47_nand_0.sky130_hd_inv_1_38.Y uo_out[7] 0.557f
C2673 sky130_hd_ro47_nand_0.sky130_hd_inv_1_39.Y uo_out[7] 0.577f
C2674 sky130_hd_ro47_nand_0.sky130_hd_inv_1_40.Y uo_out[7] 0.548f
C2675 sky130_hd_ro47_nand_0.sky130_hd_inv_1_41.Y uo_out[7] 0.538f
C2676 sky130_hd_ro47_nand_0.sky130_hd_inv_1_42.Y uo_out[7] 0.526f
C2677 sky130_hd_ro47_nand_0.sky130_hd_inv_1_43.Y uo_out[7] 0.516f
C2678 sky130_hd_ro47_nand_0.sky130_hd_inv_1_44.Y uo_out[7] 0.514f
C2679 sky130_hd_ro47_nand_0.sky130_hd_inv_1_45.Y uo_out[7] 0.514f
C2680 sky130_hd_ro47_nand_0.sky130_hd_nand2_1_0.Y uo_out[7] 0.739f
C2681 a_6379_29870# uo_out[7] 0.00213f
C2682 sky130_hd_ro41_nand_0.sky130_hd_inv_1_10.A uo_out[7] 0.55f
C2683 sky130_hd_ro41_nand_0.sky130_hd_inv_1_9.A uo_out[7] 0.535f
C2684 sky130_hd_ro41_nand_0.sky130_hd_inv_1_8.A uo_out[7] 0.534f
C2685 sky130_hd_ro41_nand_0.sky130_hd_inv_1_7.A uo_out[7] 0.528f
C2686 sky130_hd_ro41_nand_0.sky130_hd_inv_1_6.A uo_out[7] 0.53f
C2687 sky130_hd_ro41_nand_0.sky130_hd_inv_1_5.A uo_out[7] 0.535f
C2688 sky130_hd_ro41_nand_0.sky130_hd_inv_1_4.A uo_out[7] 0.537f
C2689 sky130_hd_ro41_nand_0.sky130_hd_inv_1_3.A uo_out[7] 0.583f
C2690 sky130_hd_ro41_nand_0.sky130_hd_inv_1_2.A uo_out[7] 0.546f
C2691 sky130_hd_ro41_nand_0.sky130_hd_inv_1_1.A uo_out[7] 0.603f
C2692 sky130_hd_ro41_nand_0.sky130_hd_inv_1_12.Y uo_out[7] 0.583f
C2693 sky130_hd_ro41_nand_0.sky130_hd_inv_1_13.Y uo_out[7] 0.551f
C2694 sky130_hd_ro41_nand_0.sky130_hd_inv_1_14.Y uo_out[7] 0.539f
C2695 sky130_hd_ro41_nand_0.sky130_hd_inv_1_15.Y uo_out[7] 0.537f
C2696 sky130_hd_ro41_nand_0.sky130_hd_inv_1_16.Y uo_out[7] 0.536f
C2697 sky130_hd_ro41_nand_0.sky130_hd_inv_1_17.Y uo_out[7] 0.535f
C2698 sky130_hd_ro41_nand_0.sky130_hd_inv_1_18.Y uo_out[7] 0.532f
C2699 sky130_hd_ro41_nand_0.sky130_hd_inv_1_19.Y uo_out[7] 0.528f
C2700 sky130_hd_ro41_nand_0.sky130_hd_inv_1_20.Y uo_out[7] 0.532f
C2701 sky130_hd_ro41_nand_0.sky130_hd_inv_1_21.Y uo_out[7] 0.58f
C2702 sky130_hd_ro41_nand_0.sky130_hd_inv_1_22.Y uo_out[7] 0.541f
C2703 sky130_hd_ro41_nand_0.sky130_hd_inv_1_23.Y uo_out[7] 0.538f
C2704 sky130_hd_ro41_nand_0.sky130_hd_inv_1_24.Y uo_out[7] 0.54f
C2705 sky130_hd_ro41_nand_0.sky130_hd_inv_1_25.Y uo_out[7] 0.553f
C2706 sky130_hd_ro41_nand_0.sky130_hd_inv_1_26.Y uo_out[7] 0.577f
C2707 sky130_hd_ro41_nand_0.sky130_hd_inv_1_27.Y uo_out[7] 0.556f
C2708 sky130_hd_ro41_nand_0.sky130_hd_inv_1_28.Y uo_out[7] 0.539f
C2709 sky130_hd_ro41_nand_0.sky130_hd_inv_1_29.Y uo_out[7] 0.538f
C2710 sky130_hd_ro41_nand_0.sky130_hd_inv_1_29.A uo_out[7] 0.537f
C2711 sky130_hd_ro41_nand_0.sky130_hd_inv_1_30.Y uo_out[7] 0.58f
C2712 sky130_hd_ro41_nand_0.sky130_hd_inv_1_31.Y uo_out[7] 0.536f
C2713 sky130_hd_ro41_nand_0.sky130_hd_inv_1_32.Y uo_out[7] 0.526f
C2714 sky130_hd_ro41_nand_0.sky130_hd_inv_1_33.Y uo_out[7] 0.531f
C2715 sky130_hd_ro41_nand_0.sky130_hd_inv_1_34.Y uo_out[7] 0.534f
C2716 sky130_hd_ro41_nand_0.sky130_hd_inv_1_35.Y uo_out[7] 0.535f
C2717 sky130_hd_ro41_nand_0.sky130_hd_inv_1_36.Y uo_out[7] 0.537f
C2718 sky130_hd_ro41_nand_0.sky130_hd_inv_1_37.Y uo_out[7] 0.524f
C2719 sky130_hd_ro41_nand_0.sky130_hd_inv_1_38.Y uo_out[7] 0.523f
C2720 sky130_hd_ro41_nand_0.sky130_hd_inv_1_39.Y uo_out[7] 0.539f
C2721 sky130_hd_ro41_nand_0.sky130_hd_nand2_1_0.Y uo_out[7] 0.764f
C2722 sky130_hd_xor_block_0.sky130_hd_inv_1_1.Y uo_out[7] 0.58f
C2723 sky130_hd_xor_block_0.XORB uo_out[7] 11.9f
C2724 a_25118_30583# uo_out[7] 0.00552f
C2725 a_25118_30833# uo_out[7] 0.00617f
C2726 a_24950_30833# uo_out[7] 0.00189f
C2727 a_24868_30833# uo_out[7] 0.397f
C2728 sky130_hd_xor_block_0.sky130_hd_xor2_1_0.A uo_out[7] 0.965f
C2729 sky130_hd_xor_block_0.sky130_hd_xor2_1_0.B uo_out[7] 0.564f
C2730 sky130_hd_xor_block_0.sky130_hd_inv_1_3.A uo_out[7] 0.563f
C2731 sky130_hd_xor_block_1.sky130_hd_inv_1_1.Y uo_out[7] 0.578f
C2732 sky130_hd_xor_block_1.XORB uo_out[7] 11.5f
C2733 a_23186_31740# uo_out[7] 0.00552f
C2734 sky130_hd_xor_block_1.XOROUT uo_out[7] 1.54f
C2735 a_23186_31990# uo_out[7] 0.00722f
C2736 a_23018_31990# uo_out[7] 0.00212f
C2737 a_7207_31915# uo_out[7] 0.00206f
C2738 a_22936_31990# uo_out[7] 0.398f
C2739 sky130_hd_xor_block_1.sky130_hd_xor2_1_0.A uo_out[7] 0.967f
C2740 sky130_hd_xor_block_1.sky130_hd_xor2_1_0.B uo_out[7] 0.561f
C2741 sky130_hd_xor_block_1.sky130_hd_inv_1_3.A uo_out[7] 0.562f
C2742 sky130_hd_ro37_nand_0.sky130_hd_inv_1_6.A uo_out[7] 0.548f
C2743 sky130_hd_ro37_nand_0.sky130_hd_inv_1_5.A uo_out[7] 0.528f
C2744 sky130_hd_ro37_nand_0.sky130_hd_inv_1_4.A uo_out[7] 0.527f
C2745 sky130_hd_ro37_nand_0.sky130_hd_inv_1_3.A uo_out[7] 0.572f
C2746 sky130_hd_ro37_nand_0.sky130_hd_inv_1_2.A uo_out[7] 0.535f
C2747 sky130_hd_ro37_nand_0.sky130_hd_inv_1_1.A uo_out[7] 0.575f
C2748 sky130_hd_ro37_nand_0.sky130_hd_inv_1_8.Y uo_out[7] 0.538f
C2749 sky130_hd_ro37_nand_0.sky130_hd_inv_1_9.Y uo_out[7] 0.535f
C2750 sky130_hd_ro37_nand_0.sky130_hd_inv_1_10.Y uo_out[7] 0.554f
C2751 sky130_hd_ro37_nand_0.sky130_hd_inv_1_11.Y uo_out[7] 0.578f
C2752 sky130_hd_ro37_nand_0.sky130_hd_inv_1_12.Y uo_out[7] 0.546f
C2753 sky130_hd_ro37_nand_0.sky130_hd_inv_1_13.Y uo_out[7] 0.533f
C2754 sky130_hd_ro37_nand_0.sky130_hd_inv_1_14.Y uo_out[7] 0.531f
C2755 sky130_hd_ro37_nand_0.sky130_hd_inv_1_15.Y uo_out[7] 0.53f
C2756 sky130_hd_ro37_nand_0.sky130_hd_inv_1_16.Y uo_out[7] 0.529f
C2757 sky130_hd_ro37_nand_0.sky130_hd_inv_1_17.Y uo_out[7] 0.571f
C2758 sky130_hd_ro37_nand_0.sky130_hd_inv_1_18.Y uo_out[7] 0.532f
C2759 sky130_hd_ro37_nand_0.sky130_hd_inv_1_19.Y uo_out[7] 0.528f
C2760 sky130_hd_ro37_nand_0.sky130_hd_inv_1_20.Y uo_out[7] 0.53f
C2761 sky130_hd_ro37_nand_0.sky130_hd_inv_1_21.Y uo_out[7] 0.53f
C2762 sky130_hd_ro37_nand_0.sky130_hd_inv_1_22.Y uo_out[7] 0.532f
C2763 sky130_hd_ro37_nand_0.sky130_hd_inv_1_23.Y uo_out[7] 0.533f
C2764 sky130_hd_ro37_nand_0.sky130_hd_inv_1_24.Y uo_out[7] 0.549f
C2765 sky130_hd_ro37_nand_0.sky130_hd_inv_1_25.Y uo_out[7] 0.575f
C2766 sky130_hd_ro37_nand_0.sky130_hd_inv_1_25.A uo_out[7] 0.553f
C2767 sky130_hd_ro37_nand_0.sky130_hd_inv_1_26.Y uo_out[7] 0.578f
C2768 sky130_hd_ro37_nand_0.sky130_hd_inv_1_27.Y uo_out[7] 0.537f
C2769 sky130_hd_ro37_nand_0.sky130_hd_inv_1_28.Y uo_out[7] 0.53f
C2770 sky130_hd_ro37_nand_0.sky130_hd_inv_1_29.Y uo_out[7] 0.529f
C2771 sky130_hd_ro37_nand_0.sky130_hd_inv_1_30.Y uo_out[7] 0.527f
C2772 sky130_hd_ro37_nand_0.sky130_hd_inv_1_31.Y uo_out[7] 0.526f
C2773 sky130_hd_ro37_nand_0.sky130_hd_inv_1_32.Y uo_out[7] 0.527f
C2774 sky130_hd_ro37_nand_0.sky130_hd_inv_1_33.Y uo_out[7] 0.528f
C2775 sky130_hd_ro37_nand_0.sky130_hd_inv_1_34.Y uo_out[7] 0.53f
C2776 sky130_hd_ro37_nand_0.sky130_hd_inv_1_35.Y uo_out[7] 0.532f
C2777 sky130_hd_ro37_nand_0.sky130_hd_nand2_1_0.Y uo_out[7] 0.759f
C2778 sky130_hd_xor_block_2.sky130_hd_inv_1_1.Y uo_out[7] 0.579f
C2779 sky130_hd_xor_block_2.XORB uo_out[7] 7.92f
C2780 a_21429_33018# uo_out[7] 0.00552f
C2781 sky130_hd_xor_block_2.XOROUT uo_out[7] 1.49f
C2782 a_21429_33268# uo_out[7] 0.00767f
C2783 a_21261_33268# uo_out[7] 0.00214f
C2784 a_21179_33268# uo_out[7] 0.399f
C2785 sky130_hd_xor_block_2.sky130_hd_xor2_1_0.A uo_out[7] 0.964f
C2786 sky130_hd_xor_block_2.sky130_hd_xor2_1_0.B uo_out[7] 0.559f
C2787 sky130_hd_xor_block_2.sky130_hd_inv_1_3.A uo_out[7] 0.561f
C2788 sky130_hd_xor_block_3.sky130_hd_inv_1_1.Y uo_out[7] 0.578f
C2789 sky130_hd_xor_block_3.XORB uo_out[7] 6.04f
C2790 a_19695_33682# uo_out[7] 0.00552f
C2791 sky130_hd_xor_block_3.XOROUT uo_out[7] 1.2f
C2792 a_19695_33932# uo_out[7] 0.00505f
C2793 a_19527_33932# uo_out[7] 0.00165f
C2794 a_8679_33959# uo_out[7] 0.00202f
C2795 a_19445_33932# uo_out[7] 0.393f
C2796 sky130_hd_xor_block_3.sky130_hd_xor2_1_0.A uo_out[7] 0.941f
C2797 sky130_hd_xor_block_3.sky130_hd_xor2_1_0.B uo_out[7] 0.552f
C2798 sky130_hd_xor_block_3.sky130_hd_inv_1_3.A uo_out[7] 0.551f
C2799 sky130_hd_ro33_nand_0.sky130_hd_inv_1_1.Y uo_out[7] 0.539f
C2800 sky130_hd_ro33_nand_0.sky130_hd_inv_1_2.Y uo_out[7] 0.53f
C2801 sky130_hd_ro33_nand_0.sky130_hd_inv_1_3.Y uo_out[7] 0.529f
C2802 sky130_hd_ro33_nand_0.sky130_hd_inv_1_4.Y uo_out[7] 0.527f
C2803 sky130_hd_ro33_nand_0.sky130_hd_inv_1_5.Y uo_out[7] 0.53f
C2804 sky130_hd_ro33_nand_0.sky130_hd_inv_1_6.Y uo_out[7] 0.533f
C2805 sky130_hd_ro33_nand_0.sky130_hd_inv_1_7.Y uo_out[7] 0.534f
C2806 sky130_hd_ro33_nand_0.sky130_hd_inv_1_8.Y uo_out[7] 0.536f
C2807 sky130_hd_ro33_nand_0.sky130_hd_inv_1_9.Y uo_out[7] 0.537f
C2808 sky130_hd_ro33_nand_0.sky130_hd_inv_1_10.Y uo_out[7] 0.544f
C2809 sky130_hd_ro33_nand_0.sky130_hd_inv_1_11.Y uo_out[7] 0.573f
C2810 sky130_hd_ro33_nand_0.sky130_hd_inv_1_12.Y uo_out[7] 0.604f
C2811 sky130_hd_ro33_nand_0.sky130_hd_inv_1_13.Y uo_out[7] 0.542f
C2812 sky130_hd_ro33_nand_0.sky130_hd_inv_1_14.Y uo_out[7] 0.535f
C2813 sky130_hd_ro33_nand_0.sky130_hd_inv_1_15.Y uo_out[7] 0.534f
C2814 sky130_hd_ro33_nand_0.sky130_hd_inv_1_16.Y uo_out[7] 0.533f
C2815 sky130_hd_ro33_nand_0.sky130_hd_inv_1_17.Y uo_out[7] 0.53f
C2816 sky130_hd_ro33_nand_0.sky130_hd_inv_1_18.Y uo_out[7] 0.528f
C2817 sky130_hd_ro33_nand_0.sky130_hd_inv_1_19.Y uo_out[7] 0.53f
C2818 sky130_hd_ro33_nand_0.sky130_hd_inv_1_20.Y uo_out[7] 0.533f
C2819 sky130_hd_ro33_nand_0.sky130_hd_inv_1_21.Y uo_out[7] 0.535f
C2820 sky130_hd_ro33_nand_0.sky130_hd_inv_1_22.Y uo_out[7] 0.581f
C2821 sky130_hd_ro33_nand_0.sky130_hd_inv_1_23.Y uo_out[7] 0.542f
C2822 sky130_hd_ro33_nand_0.sky130_hd_inv_1_24.Y uo_out[7] 0.551f
C2823 sky130_hd_ro33_nand_0.sky130_hd_inv_1_25.Y uo_out[7] 0.575f
C2824 sky130_hd_ro33_nand_0.sky130_hd_inv_1_26.Y uo_out[7] 0.553f
C2825 sky130_hd_ro33_nand_0.sky130_hd_inv_1_27.Y uo_out[7] 0.537f
C2826 sky130_hd_ro33_nand_0.sky130_hd_inv_1_28.Y uo_out[7] 0.536f
C2827 sky130_hd_ro33_nand_0.sky130_hd_inv_1_29.Y uo_out[7] 0.534f
C2828 sky130_hd_ro33_nand_0.sky130_hd_inv_1_30.Y uo_out[7] 0.533f
C2829 sky130_hd_ro33_nand_0.sky130_hd_inv_1_31.Y uo_out[7] 0.533f
C2830 sky130_hd_ro33_nand_0.sky130_hd_nand2_1_0.Y uo_out[7] 0.759f
C2831 sky130_hd_xor_block_3.XORA uo_out[7] 5.77f
C2832 a_24479_35563# uo_out[7] 0.0103f
C2833 a_24058_35563# uo_out[7] 0.00637f
C2834 a_24677_35563# uo_out[7] 0.0684f
C2835 a_24506_35929# uo_out[7] 0.00142f
C2836 a_24081_35929# uo_out[7] 0.00178f
C2837 a_22414_35563# uo_out[7] 0.0101f
C2838 a_21993_35563# uo_out[7] 0.00631f
C2839 sky130_hd_xor_block_0.XOROUT uo_out[7] 3.43f
C2840 a_24259_35563# uo_out[7] 0.297f
C2841 a_24330_35537# uo_out[7] 0.25f
C2842 a_24123_35537# uo_out[7] 0.572f
C2843 a_24130_35837# uo_out[7] 0.481f
C2844 a_23839_35537# uo_out[7] 0.322f
C2845 a_23743_35715# uo_out[7] 0.412f
C2846 a_22612_35563# uo_out[7] 0.0682f
C2847 a_22441_35929# uo_out[7] 0.00142f
C2848 a_22016_35929# uo_out[7] 0.00178f
C2849 sky130_hd_dfxtp_1_1.Q uo_out[7] 0.941f
C2850 a_22194_35563# uo_out[7] 0.296f
C2851 a_22265_35537# uo_out[7] 0.247f
C2852 a_22058_35537# uo_out[7] 0.586f
C2853 a_22065_35837# uo_out[7] 0.48f
C2854 a_21774_35537# uo_out[7] 0.321f
C2855 a_21678_35715# uo_out[7] 0.411f
C2856 sky130_hd_inv_1_0.A uo_out[7] 0.556f
C2857 sky130_hd_inv_4_0.A uo_out[7] 0.776f
C2858 sky130_hd_tapvpwrvgnd_1_6.VPWR uo_out[7] 0.367f $ **FLOATING
C2859 sky130_hd_tapvpwrvgnd_1_7.VPWR uo_out[7] 0.374f $ **FLOATING
.ends
