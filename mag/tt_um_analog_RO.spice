* SPICE3 file created from tt_um_analog_RO.ext - technology: sky130A

.subckt tt_um_analog_RO clk ena rst_n ua[0] ua[1] ua[2] ua[3] ua[4] ua[5] ua[6] ua[7]
+ ui_in[0] ui_in[1] ui_in[2] ui_in[3] ui_in[4] ui_in[5] ui_in[6] ui_in[7] uio_in[0]
+ uio_in[1] uio_in[2] uio_in[3] uio_in[4] uio_in[5] uio_in[6] uio_in[7] uio_oe[0]
+ uio_oe[1] uio_oe[2] uio_oe[3] uio_oe[4] uio_oe[5] uio_oe[6] uio_oe[7] uio_out[0]
+ uio_out[1] uio_out[2] uio_out[3] uio_out[4] uio_out[5] uio_out[6] uio_out[7] uo_out[0]
+ uo_out[1] uo_out[2] uo_out[3] uo_out[4] uo_out[5] uo_out[6] uo_out[7] VDPWR VGND
C0 VDPWR VGND 15.8f
C1 VGND ua[0] 2.3f
Xsky130_hd_ro32_nand_0 VGND VDPWR ena ua[0] sky130_hd_ro32_nand
C2 VDPWR 0 28.8f
C3 ua[0] 0 5.43f
C4 ena 0 22f
C5 VGND 0 34.6f
.ends
